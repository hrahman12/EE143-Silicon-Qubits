* QBF-X2 two-flying-fluxon collision processor - PRELIMINARY design netlist (not fabrication-ready)
* rows ['D_A', 'A0', 'A1', 'B1', 'B0', 'D_B']; 362 cells per row, pitch 2.0 um; design speed beta = 0.450
* coupler k = 0.01778 (L_s = 11.62 pH), c = 0.0875 (C_c = 0.212 fF)
.model JJR jj(rtype=0, cap=1.917e-15, icrit=8.053e-08)
.model JJM jj(rtype=0, cap=1.213e-15, icrit=5.094e-08)
.model JJI jj(rtype=1, cap=3.835e-15, icrit=1.611e-07, rn=2k, r0=200k)
BD_A_0 D_A_0 0 JJR area=1
CD_A_0 D_A_0 0 5.038e-16
LD_A_0 D_A_0 D_A_1 6.5385e-10
BD_A_1 D_A_1 0 JJR area=1
CD_A_1 D_A_1 0 5.038e-16
LD_A_1 D_A_1 D_A_2 6.5385e-10
BD_A_2 D_A_2 0 JJR area=1
CD_A_2 D_A_2 0 5.038e-16
LD_A_2 D_A_2 D_A_3 6.5385e-10
BD_A_3 D_A_3 0 JJR area=1
CD_A_3 D_A_3 0 5.038e-16
LD_A_3 D_A_3 D_A_4 6.5385e-10
BD_A_4 D_A_4 0 JJR area=1
CD_A_4 D_A_4 0 5.038e-16
LD_A_4 D_A_4 D_A_5 6.5385e-10
BD_A_5 D_A_5 0 JJR area=1
CD_A_5 D_A_5 0 5.038e-16
LD_A_5 D_A_5 D_A_6 6.5385e-10
BD_A_6 D_A_6 0 JJR area=1
CD_A_6 D_A_6 0 5.038e-16
LD_A_6 D_A_6 D_A_7 6.5385e-10
BD_A_7 D_A_7 0 JJR area=1
CD_A_7 D_A_7 0 5.038e-16
LD_A_7 D_A_7 D_A_8 6.5385e-10
BD_A_8 D_A_8 0 JJR area=1
CD_A_8 D_A_8 0 5.038e-16
LD_A_8 D_A_8 D_A_9 6.5385e-10
BD_A_9 D_A_9 0 JJR area=1
CD_A_9 D_A_9 0 5.038e-16
LD_A_9 D_A_9 D_A_10 6.5385e-10
BD_A_10 D_A_10 0 JJR area=1
CD_A_10 D_A_10 0 5.038e-16
LD_A_10 D_A_10 D_A_11 6.5385e-10
BD_A_11 D_A_11 0 JJR area=1
CD_A_11 D_A_11 0 5.038e-16
LD_A_11 D_A_11 D_A_12 6.5385e-10
BD_A_12 D_A_12 0 JJR area=1
CD_A_12 D_A_12 0 5.038e-16
LD_A_12 D_A_12 D_A_13 6.5385e-10
BD_A_13 D_A_13 0 JJR area=1
CD_A_13 D_A_13 0 5.038e-16
LD_A_13 D_A_13 D_A_14 6.5385e-10
BD_A_14 D_A_14 0 JJR area=1
CD_A_14 D_A_14 0 5.038e-16
LD_A_14 D_A_14 D_A_15 6.5385e-10
BD_A_15 D_A_15 0 JJR area=1
CD_A_15 D_A_15 0 5.038e-16
LD_A_15 D_A_15 D_A_16 6.5385e-10
BD_A_16 D_A_16 0 JJR area=1
CD_A_16 D_A_16 0 5.038e-16
LD_A_16 D_A_16 D_A_17 6.5385e-10
BD_A_17 D_A_17 0 JJR area=1
CD_A_17 D_A_17 0 5.038e-16
LD_A_17 D_A_17 D_A_18 6.5385e-10
BD_A_18 D_A_18 0 JJR area=1
CD_A_18 D_A_18 0 5.038e-16
LD_A_18 D_A_18 D_A_19 6.5385e-10
BD_A_19 D_A_19 0 JJR area=1
CD_A_19 D_A_19 0 5.038e-16
LD_A_19 D_A_19 D_A_20 6.5385e-10
BD_A_20 D_A_20 0 JJR area=1
CD_A_20 D_A_20 0 5.038e-16
LD_A_20 D_A_20 D_A_21 6.5385e-10
BD_A_21 D_A_21 0 JJR area=1
CD_A_21 D_A_21 0 5.038e-16
LD_A_21 D_A_21 D_A_22 6.5385e-10
BD_A_22 D_A_22 0 JJR area=1
CD_A_22 D_A_22 0 5.038e-16
LD_A_22 D_A_22 D_A_23 6.5385e-10
BD_A_23 D_A_23 0 JJR area=1
CD_A_23 D_A_23 0 5.038e-16
LD_A_23 D_A_23 D_A_24 6.5385e-10
BD_A_24 D_A_24 0 JJR area=1
CD_A_24 D_A_24 0 5.038e-16
LD_A_24 D_A_24 D_A_25 6.5385e-10
BD_A_25 D_A_25 0 JJR area=1
CD_A_25 D_A_25 0 5.038e-16
LD_A_25 D_A_25 D_A_26 6.5385e-10
BD_A_26 D_A_26 0 JJR area=1
CD_A_26 D_A_26 0 5.038e-16
LD_A_26 D_A_26 D_A_27 6.5385e-10
BD_A_27 D_A_27 0 JJR area=1
CD_A_27 D_A_27 0 5.038e-16
LD_A_27 D_A_27 D_A_28 6.5385e-10
BD_A_28 D_A_28 0 JJR area=1
CD_A_28 D_A_28 0 5.038e-16
LD_A_28 D_A_28 D_A_29 6.5385e-10
BD_A_29 D_A_29 0 JJR area=1
CD_A_29 D_A_29 0 5.038e-16
LD_A_29 D_A_29 D_A_30 6.5385e-10
BD_A_30 D_A_30 0 JJR area=1
CD_A_30 D_A_30 0 5.038e-16
LD_A_30 D_A_30 D_A_31 6.5385e-10
BD_A_31 D_A_31 0 JJR area=1
CD_A_31 D_A_31 0 5.038e-16
LD_A_31 D_A_31 D_A_32 6.5385e-10
BD_A_32 D_A_32 0 JJR area=1
CD_A_32 D_A_32 0 5.038e-16
LD_A_32 D_A_32 D_A_33 6.5385e-10
BD_A_33 D_A_33 0 JJR area=1
CD_A_33 D_A_33 0 5.038e-16
LD_A_33 D_A_33 D_A_34 6.5385e-10
BD_A_34 D_A_34 0 JJR area=1
CD_A_34 D_A_34 0 5.038e-16
LD_A_34 D_A_34 D_A_35 6.5385e-10
BD_A_35 D_A_35 0 JJR area=1
CD_A_35 D_A_35 0 5.038e-16
LD_A_35 D_A_35 D_A_36 6.5385e-10
BD_A_36 D_A_36 0 JJR area=1
CD_A_36 D_A_36 0 5.038e-16
LD_A_36 D_A_36 D_A_37 6.5385e-10
BD_A_37 D_A_37 0 JJR area=1
CD_A_37 D_A_37 0 5.038e-16
LD_A_37 D_A_37 D_A_38 6.5385e-10
BD_A_38 D_A_38 0 JJR area=1
CD_A_38 D_A_38 0 5.038e-16
LD_A_38 D_A_38 D_A_39 6.5385e-10
BD_A_39 D_A_39 0 JJR area=1
CD_A_39 D_A_39 0 5.038e-16
LD_A_39 D_A_39 D_A_40 6.5385e-10
BD_A_40 D_A_40 0 JJR area=1
CD_A_40 D_A_40 0 5.038e-16
LD_A_40 D_A_40 D_A_41 6.5385e-10
BD_A_41 D_A_41 0 JJR area=1
CD_A_41 D_A_41 0 5.038e-16
LD_A_41 D_A_41 D_A_42 6.5385e-10
BD_A_42 D_A_42 0 JJR area=1
CD_A_42 D_A_42 0 5.038e-16
LD_A_42 D_A_42 D_A_43 6.5385e-10
BD_A_43 D_A_43 0 JJR area=1
CD_A_43 D_A_43 0 5.038e-16
LD_A_43 D_A_43 D_A_44 6.5385e-10
BD_A_44 D_A_44 0 JJR area=1
CD_A_44 D_A_44 0 5.038e-16
LD_A_44 D_A_44 D_A_45 6.5385e-10
BD_A_45 D_A_45 0 JJR area=1
CD_A_45 D_A_45 0 5.038e-16
LD_A_45 D_A_45 D_A_46 6.5385e-10
BD_A_46 D_A_46 0 JJR area=1
CD_A_46 D_A_46 0 5.038e-16
LD_A_46 D_A_46 D_A_47 6.5385e-10
BD_A_47 D_A_47 0 JJR area=1
CD_A_47 D_A_47 0 5.038e-16
LD_A_47 D_A_47 D_A_48 6.5385e-10
BD_A_48 D_A_48 0 JJR area=1
CD_A_48 D_A_48 0 5.038e-16
LD_A_48 D_A_48 D_A_49 6.5385e-10
BD_A_49 D_A_49 0 JJR area=1
CD_A_49 D_A_49 0 5.038e-16
LD_A_49 D_A_49 D_A_50 6.5385e-10
BD_A_50 D_A_50 0 JJR area=1
CD_A_50 D_A_50 0 5.038e-16
LD_A_50 D_A_50 D_A_51 6.5385e-10
BD_A_51 D_A_51 0 JJR area=1
CD_A_51 D_A_51 0 5.038e-16
LD_A_51 D_A_51 D_A_52 6.5385e-10
BD_A_52 D_A_52 0 JJR area=1
CD_A_52 D_A_52 0 5.038e-16
LD_A_52 D_A_52 D_A_53 6.5385e-10
BD_A_53 D_A_53 0 JJR area=1
CD_A_53 D_A_53 0 5.038e-16
LD_A_53 D_A_53 D_A_54 6.5385e-10
BD_A_54 D_A_54 0 JJR area=1
CD_A_54 D_A_54 0 5.038e-16
LD_A_54 D_A_54 D_A_55 6.5385e-10
BD_A_55 D_A_55 0 JJR area=1
CD_A_55 D_A_55 0 5.038e-16
LD_A_55 D_A_55 D_A_56 6.5385e-10
BD_A_56 D_A_56 0 JJR area=1
CD_A_56 D_A_56 0 5.038e-16
LD_A_56 D_A_56 D_A_57 6.5385e-10
BD_A_57 D_A_57 0 JJR area=1
CD_A_57 D_A_57 0 5.038e-16
LD_A_57 D_A_57 D_A_58 6.5385e-10
BD_A_58 D_A_58 0 JJR area=1
CD_A_58 D_A_58 0 5.038e-16
LD_A_58 D_A_58 D_A_59 6.5385e-10
BD_A_59 D_A_59 0 JJR area=1
CD_A_59 D_A_59 0 5.038e-16
LD_A_59 D_A_59 D_A_60 6.5385e-10
BD_A_60 D_A_60 0 JJR area=1
CD_A_60 D_A_60 0 5.038e-16
LD_A_60 D_A_60 D_A_61 6.5385e-10
BD_A_61 D_A_61 0 JJR area=1
CD_A_61 D_A_61 0 5.038e-16
LD_A_61 D_A_61 D_A_62 6.5385e-10
BD_A_62 D_A_62 0 JJR area=1
CD_A_62 D_A_62 0 5.038e-16
LD_A_62 D_A_62 D_A_63 6.5385e-10
BD_A_63 D_A_63 0 JJR area=1
CD_A_63 D_A_63 0 5.038e-16
LD_A_63 D_A_63 D_A_64 6.5385e-10
BD_A_64 D_A_64 0 JJR area=1
CD_A_64 D_A_64 0 5.038e-16
LD_A_64 D_A_64 D_A_65 6.5385e-10
BD_A_65 D_A_65 0 JJR area=1
CD_A_65 D_A_65 0 5.038e-16
LD_A_65 D_A_65 D_A_66 6.5385e-10
BD_A_66 D_A_66 0 JJR area=1
CD_A_66 D_A_66 0 5.038e-16
LD_A_66 D_A_66 D_A_67 6.5385e-10
BD_A_67 D_A_67 0 JJR area=1
CD_A_67 D_A_67 0 5.038e-16
LD_A_67 D_A_67 D_A_68 6.5385e-10
BD_A_68 D_A_68 0 JJR area=1
CD_A_68 D_A_68 0 5.038e-16
LD_A_68 D_A_68 D_A_69 6.5385e-10
BD_A_69 D_A_69 0 JJR area=1
CD_A_69 D_A_69 0 5.038e-16
LD_A_69 D_A_69 D_A_70 6.5385e-10
BD_A_70 D_A_70 0 JJR area=1
CD_A_70 D_A_70 0 5.038e-16
LD_A_70 D_A_70 D_A_71 6.5385e-10
BD_A_71 D_A_71 0 JJR area=1
CD_A_71 D_A_71 0 5.038e-16
LD_A_71 D_A_71 D_A_72 6.5385e-10
BD_A_72 D_A_72 0 JJR area=1
CD_A_72 D_A_72 0 5.038e-16
LD_A_72 D_A_72 D_A_73 6.5385e-10
BD_A_73 D_A_73 0 JJR area=1
CD_A_73 D_A_73 0 5.038e-16
LD_A_73 D_A_73 D_A_74 6.5385e-10
BD_A_74 D_A_74 0 JJR area=1
CD_A_74 D_A_74 0 5.038e-16
LD_A_74 D_A_74 D_A_75 6.5385e-10
BD_A_75 D_A_75 0 JJR area=1
CD_A_75 D_A_75 0 5.038e-16
LD_A_75 D_A_75 D_A_76 6.5385e-10
BD_A_76 D_A_76 0 JJR area=1
CD_A_76 D_A_76 0 5.038e-16
LD_A_76 D_A_76 D_A_77 6.5385e-10
BD_A_77 D_A_77 0 JJR area=1
CD_A_77 D_A_77 0 5.038e-16
LD_A_77 D_A_77 D_A_78 6.5385e-10
BD_A_78 D_A_78 0 JJR area=1
CD_A_78 D_A_78 0 5.038e-16
LD_A_78 D_A_78 D_A_79 6.5385e-10
BD_A_79 D_A_79 0 JJR area=1
CD_A_79 D_A_79 0 5.038e-16
LD_A_79 D_A_79 D_A_80 6.5385e-10
BD_A_80 D_A_80 0 JJR area=1
CD_A_80 D_A_80 0 5.038e-16
LD_A_80 D_A_80 D_A_81 6.5385e-10
BD_A_81 D_A_81 0 JJR area=1
CD_A_81 D_A_81 0 5.038e-16
LD_A_81 D_A_81 D_A_82 6.5385e-10
BD_A_82 D_A_82 0 JJR area=1
CD_A_82 D_A_82 0 5.038e-16
LD_A_82 D_A_82 D_A_83 6.5385e-10
BD_A_83 D_A_83 0 JJR area=1
CD_A_83 D_A_83 0 5.038e-16
LD_A_83 D_A_83 D_A_84 6.5385e-10
BD_A_84 D_A_84 0 JJR area=1
CD_A_84 D_A_84 0 5.038e-16
LD_A_84 D_A_84 D_A_85 6.5385e-10
BD_A_85 D_A_85 0 JJR area=1
CD_A_85 D_A_85 0 5.038e-16
LD_A_85 D_A_85 D_A_86 6.5385e-10
BD_A_86 D_A_86 0 JJR area=1
CD_A_86 D_A_86 0 5.038e-16
LD_A_86 D_A_86 D_A_87 6.5385e-10
BD_A_87 D_A_87 0 JJR area=1
CD_A_87 D_A_87 0 5.038e-16
LD_A_87 D_A_87 D_A_88 6.5385e-10
BD_A_88 D_A_88 0 JJR area=1
CD_A_88 D_A_88 0 5.038e-16
LD_A_88 D_A_88 D_A_89 6.5385e-10
BD_A_89 D_A_89 0 JJR area=1
CD_A_89 D_A_89 0 5.038e-16
LD_A_89 D_A_89 D_A_90 6.5385e-10
BD_A_90 D_A_90 0 JJR area=1
CD_A_90 D_A_90 0 5.038e-16
LD_A_90 D_A_90 D_A_91 6.5385e-10
BD_A_91 D_A_91 0 JJR area=1
CD_A_91 D_A_91 0 5.038e-16
LD_A_91 D_A_91 D_A_92 6.5385e-10
BD_A_92 D_A_92 0 JJR area=1
CD_A_92 D_A_92 0 5.038e-16
LD_A_92 D_A_92 D_A_93 6.5385e-10
BD_A_93 D_A_93 0 JJR area=1
CD_A_93 D_A_93 0 5.038e-16
LD_A_93 D_A_93 D_A_94 6.5385e-10
BD_A_94 D_A_94 0 JJR area=1
CD_A_94 D_A_94 0 5.038e-16
LD_A_94 D_A_94 D_A_95 6.5385e-10
BD_A_95 D_A_95 0 JJR area=1
CD_A_95 D_A_95 0 5.038e-16
LD_A_95 D_A_95 D_A_96 6.5385e-10
BD_A_96 D_A_96 0 JJR area=1
CD_A_96 D_A_96 0 5.038e-16
LD_A_96 D_A_96 D_A_97 6.5385e-10
BD_A_97 D_A_97 0 JJR area=1
CD_A_97 D_A_97 0 5.038e-16
LD_A_97 D_A_97 D_A_98 6.5385e-10
BD_A_98 D_A_98 0 JJR area=1
CD_A_98 D_A_98 0 5.038e-16
LD_A_98 D_A_98 D_A_99 6.5385e-10
BD_A_99 D_A_99 0 JJR area=1
CD_A_99 D_A_99 0 5.038e-16
LD_A_99 D_A_99 D_A_100 6.5385e-10
BD_A_100 D_A_100 0 JJR area=1
CD_A_100 D_A_100 0 5.038e-16
LD_A_100 D_A_100 D_A_101 6.5385e-10
BD_A_101 D_A_101 0 JJR area=1
CD_A_101 D_A_101 0 5.038e-16
LD_A_101 D_A_101 D_A_102 6.5385e-10
BD_A_102 D_A_102 0 JJR area=1
CD_A_102 D_A_102 0 5.038e-16
LD_A_102 D_A_102 D_A_103 6.5385e-10
BD_A_103 D_A_103 0 JJR area=1
CD_A_103 D_A_103 0 5.038e-16
LD_A_103 D_A_103 D_A_104 6.5385e-10
BD_A_104 D_A_104 0 JJR area=1
CD_A_104 D_A_104 0 5.038e-16
LD_A_104 D_A_104 D_A_105 6.5385e-10
BD_A_105 D_A_105 0 JJR area=1
CD_A_105 D_A_105 0 5.038e-16
LD_A_105 D_A_105 D_A_106 6.5385e-10
BD_A_106 D_A_106 0 JJR area=1
CD_A_106 D_A_106 0 5.038e-16
LD_A_106 D_A_106 D_A_107 6.5385e-10
BD_A_107 D_A_107 0 JJR area=1
CD_A_107 D_A_107 0 5.038e-16
LD_A_107 D_A_107 D_A_108 6.5385e-10
BD_A_108 D_A_108 0 JJR area=1
CD_A_108 D_A_108 0 5.038e-16
LD_A_108 D_A_108 D_A_109 6.5385e-10
BD_A_109 D_A_109 0 JJR area=1
CD_A_109 D_A_109 0 5.038e-16
LD_A_109 D_A_109 D_A_110 6.5385e-10
BD_A_110 D_A_110 0 JJR area=1
CD_A_110 D_A_110 0 5.038e-16
LD_A_110 D_A_110 D_A_111 6.5384e-10
BD_A_111 D_A_111 SDA_111 JJR area=1
CD_A_111 D_A_111 0 5.037e-16
LD_A_111 D_A_111 D_A_112 6.5382e-10
BD_A_112 D_A_112 SDA_112 JJR area=1
CD_A_112 D_A_112 0 5.031e-16
LD_A_112 D_A_112 D_A_113 6.5377e-10
BD_A_113 D_A_113 SDA_113 JJR area=1
CD_A_113 D_A_113 0 5.018e-16
LD_A_113 D_A_113 D_A_114 6.5368e-10
BD_A_114 D_A_114 SDA_114 JJR area=1
CD_A_114 D_A_114 0 4.998e-16
LD_A_114 D_A_114 D_A_115 6.5356e-10
BD_A_115 D_A_115 SDA_115 JJR area=1
CD_A_115 D_A_115 0 4.973e-16
LD_A_115 D_A_115 D_A_116 6.534e-10
BD_A_116 D_A_116 SDA_116 JJR area=1
CD_A_116 D_A_116 0 4.941e-16
LD_A_116 D_A_116 D_A_117 6.5321e-10
BD_A_117 D_A_117 SDA_117 JJR area=1
CD_A_117 D_A_117 0 4.903e-16
LD_A_117 D_A_117 D_A_118 6.5299e-10
BD_A_118 D_A_118 SDA_118 JJR area=1
CD_A_118 D_A_118 0 4.86e-16
LD_A_118 D_A_118 D_A_119 6.5273e-10
BD_A_119 D_A_119 SDA_119 JJR area=1
CD_A_119 D_A_119 0 4.811e-16
LD_A_119 D_A_119 D_A_120 6.5245e-10
BD_A_120 D_A_120 SDA_120 JJR area=1
CD_A_120 D_A_120 0 4.757e-16
LD_A_120 D_A_120 D_A_121 6.5214e-10
BD_A_121 D_A_121 SDA_121 JJR area=1
CD_A_121 D_A_121 0 4.698e-16
LD_A_121 D_A_121 D_A_122 6.5181e-10
BD_A_122 D_A_122 SDA_122 JJR area=1
CD_A_122 D_A_122 0 4.635e-16
LD_A_122 D_A_122 D_A_123 6.5145e-10
BD_A_123 D_A_123 SDA_123 JJR area=1
CD_A_123 D_A_123 0 4.567e-16
LD_A_123 D_A_123 D_A_124 6.5107e-10
BD_A_124 D_A_124 SDA_124 JJR area=1
CD_A_124 D_A_124 0 4.496e-16
LD_A_124 D_A_124 D_A_125 6.5067e-10
BD_A_125 D_A_125 SDA_125 JJR area=1
CD_A_125 D_A_125 0 4.422e-16
LD_A_125 D_A_125 D_A_126 6.5026e-10
BD_A_126 D_A_126 SDA_126 JJR area=1
CD_A_126 D_A_126 0 4.346e-16
LD_A_126 D_A_126 D_A_127 6.4983e-10
BD_A_127 D_A_127 SDA_127 JJR area=1
CD_A_127 D_A_127 0 4.267e-16
LD_A_127 D_A_127 D_A_128 6.4939e-10
BD_A_128 D_A_128 SDA_128 JJR area=1
CD_A_128 D_A_128 0 4.186e-16
LD_A_128 D_A_128 D_A_129 6.4894e-10
BD_A_129 D_A_129 SDA_129 JJR area=1
CD_A_129 D_A_129 0 4.104e-16
LD_A_129 D_A_129 D_A_130 6.4849e-10
BD_A_130 D_A_130 SDA_130 JJR area=1
CD_A_130 D_A_130 0 4.021e-16
LD_A_130 D_A_130 D_A_131 6.4803e-10
BD_A_131 D_A_131 SDA_131 JJR area=1
CD_A_131 D_A_131 0 3.938e-16
LD_A_131 D_A_131 D_A_132 6.4758e-10
BD_A_132 D_A_132 SDA_132 JJR area=1
CD_A_132 D_A_132 0 3.855e-16
LD_A_132 D_A_132 D_A_133 6.4713e-10
BD_A_133 D_A_133 SDA_133 JJR area=1
CD_A_133 D_A_133 0 3.772e-16
LD_A_133 D_A_133 D_A_134 6.4668e-10
BD_A_134 D_A_134 SDA_134 JJR area=1
CD_A_134 D_A_134 0 3.692e-16
LD_A_134 D_A_134 D_A_135 6.4624e-10
BD_A_135 D_A_135 SDA_135 JJR area=1
CD_A_135 D_A_135 0 3.613e-16
LD_A_135 D_A_135 D_A_136 6.4581e-10
BD_A_136 D_A_136 SDA_136 JJR area=1
CD_A_136 D_A_136 0 3.536e-16
LD_A_136 D_A_136 D_A_137 6.454e-10
BD_A_137 D_A_137 SDA_137 JJR area=1
CD_A_137 D_A_137 0 3.462e-16
LD_A_137 D_A_137 D_A_138 6.45e-10
BD_A_138 D_A_138 SDA_138 JJR area=1
CD_A_138 D_A_138 0 3.391e-16
LD_A_138 D_A_138 D_A_139 6.4462e-10
BD_A_139 D_A_139 SDA_139 JJR area=1
CD_A_139 D_A_139 0 3.324e-16
LD_A_139 D_A_139 D_A_140 6.4426e-10
BD_A_140 D_A_140 SDA_140 JJR area=1
CD_A_140 D_A_140 0 3.26e-16
LD_A_140 D_A_140 D_A_141 6.4393e-10
BD_A_141 D_A_141 SDA_141 JJR area=1
CD_A_141 D_A_141 0 3.201e-16
LD_A_141 D_A_141 D_A_142 6.4362e-10
BD_A_142 D_A_142 SDA_142 JJR area=1
CD_A_142 D_A_142 0 3.147e-16
LD_A_142 D_A_142 D_A_143 6.4334e-10
BD_A_143 D_A_143 SDA_143 JJR area=1
CD_A_143 D_A_143 0 3.099e-16
LD_A_143 D_A_143 D_A_144 6.4308e-10
BD_A_144 D_A_144 SDA_144 JJR area=1
CD_A_144 D_A_144 0 3.055e-16
LD_A_144 D_A_144 D_A_145 6.4286e-10
BD_A_145 D_A_145 SDA_145 JJR area=1
CD_A_145 D_A_145 0 3.017e-16
LD_A_145 D_A_145 D_A_146 6.4267e-10
BD_A_146 D_A_146 SDA_146 JJR area=1
CD_A_146 D_A_146 0 2.986e-16
LD_A_146 D_A_146 D_A_147 6.4251e-10
BD_A_147 D_A_147 SDA_147 JJR area=1
CD_A_147 D_A_147 0 2.96e-16
LD_A_147 D_A_147 D_A_148 6.4239e-10
BD_A_148 D_A_148 SDA_148 JJR area=1
CD_A_148 D_A_148 0 2.941e-16
LD_A_148 D_A_148 D_A_149 6.423e-10
BD_A_149 D_A_149 SDA_149 JJR area=1
CD_A_149 D_A_149 0 2.928e-16
LD_A_149 D_A_149 D_A_150 6.4224e-10
BD_A_150 D_A_150 SDA_150 JJR area=1
CD_A_150 D_A_150 0 2.921e-16
LD_A_150 D_A_150 D_A_151 6.4222e-10
BD_A_151 D_A_151 SDA_151 JJR area=1
CD_A_151 D_A_151 0 2.92e-16
LD_A_151 D_A_151 D_A_152 6.4222e-10
BD_A_152 D_A_152 SDA_152 JJR area=1
CD_A_152 D_A_152 0 2.92e-16
LD_A_152 D_A_152 D_A_153 6.4222e-10
BD_A_153 D_A_153 SDA_153 JJR area=1
CD_A_153 D_A_153 0 2.92e-16
LD_A_153 D_A_153 D_A_154 6.4222e-10
BD_A_154 D_A_154 SDA_154 JJR area=1
CD_A_154 D_A_154 0 2.92e-16
LD_A_154 D_A_154 D_A_155 6.4222e-10
BD_A_155 D_A_155 SDA_155 JJR area=1
CD_A_155 D_A_155 0 2.92e-16
LD_A_155 D_A_155 D_A_156 6.4222e-10
BD_A_156 D_A_156 SDA_156 JJR area=1
CD_A_156 D_A_156 0 2.92e-16
LD_A_156 D_A_156 D_A_157 6.4222e-10
BD_A_157 D_A_157 SDA_157 JJR area=1
CD_A_157 D_A_157 0 2.92e-16
LD_A_157 D_A_157 D_A_158 6.4222e-10
BD_A_158 D_A_158 SDA_158 JJR area=1
CD_A_158 D_A_158 0 2.92e-16
LD_A_158 D_A_158 D_A_159 6.4222e-10
BD_A_159 D_A_159 SDA_159 JJR area=1
CD_A_159 D_A_159 0 2.92e-16
LD_A_159 D_A_159 D_A_160 6.4222e-10
BD_A_160 D_A_160 SDA_160 JJR area=1
CD_A_160 D_A_160 0 2.92e-16
LD_A_160 D_A_160 D_A_161 6.4222e-10
BD_A_161 D_A_161 SDA_161 JJR area=1
CD_A_161 D_A_161 0 2.92e-16
LD_A_161 D_A_161 D_A_162 6.4222e-10
BD_A_162 D_A_162 SDA_162 JJR area=1
CD_A_162 D_A_162 0 2.92e-16
LD_A_162 D_A_162 D_A_163 6.4222e-10
BD_A_163 D_A_163 SDA_163 JJR area=1
CD_A_163 D_A_163 0 2.92e-16
LD_A_163 D_A_163 D_A_164 6.4222e-10
BD_A_164 D_A_164 SDA_164 JJR area=1
CD_A_164 D_A_164 0 2.92e-16
LD_A_164 D_A_164 D_A_165 6.4222e-10
BD_A_165 D_A_165 SDA_165 JJR area=1
CD_A_165 D_A_165 0 2.92e-16
LD_A_165 D_A_165 D_A_166 6.4222e-10
BD_A_166 D_A_166 SDA_166 JJR area=1
CD_A_166 D_A_166 0 2.92e-16
LD_A_166 D_A_166 D_A_167 6.4222e-10
BD_A_167 D_A_167 SDA_167 JJR area=1
CD_A_167 D_A_167 0 2.92e-16
LD_A_167 D_A_167 D_A_168 6.4222e-10
BD_A_168 D_A_168 SDA_168 JJR area=1
CD_A_168 D_A_168 0 2.92e-16
LD_A_168 D_A_168 D_A_169 6.4222e-10
BD_A_169 D_A_169 SDA_169 JJR area=1
CD_A_169 D_A_169 0 2.92e-16
LD_A_169 D_A_169 D_A_170 6.4222e-10
BD_A_170 D_A_170 SDA_170 JJR area=1
CD_A_170 D_A_170 0 2.92e-16
LD_A_170 D_A_170 D_A_171 6.4222e-10
BD_A_171 D_A_171 SDA_171 JJR area=1
CD_A_171 D_A_171 0 2.92e-16
LD_A_171 D_A_171 D_A_172 6.4222e-10
BD_A_172 D_A_172 SDA_172 JJR area=1
CD_A_172 D_A_172 0 2.92e-16
LD_A_172 D_A_172 D_A_173 6.4222e-10
BD_A_173 D_A_173 SDA_173 JJR area=1
CD_A_173 D_A_173 0 2.92e-16
LD_A_173 D_A_173 D_A_174 6.4222e-10
BD_A_174 D_A_174 SDA_174 JJR area=1
CD_A_174 D_A_174 0 2.92e-16
LD_A_174 D_A_174 D_A_175 6.4222e-10
BD_A_175 D_A_175 SDA_175 JJR area=1
CD_A_175 D_A_175 0 2.92e-16
LD_A_175 D_A_175 D_A_176 6.4222e-10
BD_A_176 D_A_176 SDA_176 JJR area=1
CD_A_176 D_A_176 0 2.92e-16
LD_A_176 D_A_176 D_A_177 6.4222e-10
BD_A_177 D_A_177 SDA_177 JJR area=1
CD_A_177 D_A_177 0 2.92e-16
LD_A_177 D_A_177 D_A_178 6.4222e-10
BD_A_178 D_A_178 SDA_178 JJR area=1
CD_A_178 D_A_178 0 2.92e-16
LD_A_178 D_A_178 D_A_179 6.4222e-10
BD_A_179 D_A_179 SDA_179 JJR area=1
CD_A_179 D_A_179 0 2.92e-16
LD_A_179 D_A_179 D_A_180 6.4222e-10
BD_A_180 D_A_180 SDA_180 JJR area=1
CD_A_180 D_A_180 0 2.92e-16
LD_A_180 D_A_180 D_A_181 6.4222e-10
BD_A_181 D_A_181 SDA_181 JJR area=1
CD_A_181 D_A_181 0 2.92e-16
LD_A_181 D_A_181 D_A_182 6.4222e-10
BD_A_182 D_A_182 SDA_182 JJR area=1
CD_A_182 D_A_182 0 2.92e-16
LD_A_182 D_A_182 D_A_183 6.4222e-10
BD_A_183 D_A_183 SDA_183 JJR area=1
CD_A_183 D_A_183 0 2.92e-16
LD_A_183 D_A_183 D_A_184 6.4222e-10
BD_A_184 D_A_184 SDA_184 JJR area=1
CD_A_184 D_A_184 0 2.92e-16
LD_A_184 D_A_184 D_A_185 6.4222e-10
BD_A_185 D_A_185 SDA_185 JJR area=1
CD_A_185 D_A_185 0 2.92e-16
LD_A_185 D_A_185 D_A_186 6.4222e-10
BD_A_186 D_A_186 SDA_186 JJR area=1
CD_A_186 D_A_186 0 2.92e-16
LD_A_186 D_A_186 D_A_187 6.4222e-10
BD_A_187 D_A_187 SDA_187 JJR area=1
CD_A_187 D_A_187 0 2.92e-16
LD_A_187 D_A_187 D_A_188 6.4222e-10
BD_A_188 D_A_188 SDA_188 JJR area=1
CD_A_188 D_A_188 0 2.92e-16
LD_A_188 D_A_188 D_A_189 6.4222e-10
BD_A_189 D_A_189 SDA_189 JJR area=1
CD_A_189 D_A_189 0 2.92e-16
LD_A_189 D_A_189 D_A_190 6.4222e-10
BD_A_190 D_A_190 SDA_190 JJR area=1
CD_A_190 D_A_190 0 2.92e-16
LD_A_190 D_A_190 D_A_191 6.4222e-10
BD_A_191 D_A_191 SDA_191 JJR area=1
CD_A_191 D_A_191 0 2.92e-16
LD_A_191 D_A_191 D_A_192 6.4222e-10
BD_A_192 D_A_192 SDA_192 JJR area=1
CD_A_192 D_A_192 0 2.92e-16
LD_A_192 D_A_192 D_A_193 6.4222e-10
BD_A_193 D_A_193 SDA_193 JJR area=1
CD_A_193 D_A_193 0 2.92e-16
LD_A_193 D_A_193 D_A_194 6.4222e-10
BD_A_194 D_A_194 SDA_194 JJR area=1
CD_A_194 D_A_194 0 2.92e-16
LD_A_194 D_A_194 D_A_195 6.4222e-10
BD_A_195 D_A_195 SDA_195 JJR area=1
CD_A_195 D_A_195 0 2.92e-16
LD_A_195 D_A_195 D_A_196 6.4222e-10
BD_A_196 D_A_196 SDA_196 JJR area=1
CD_A_196 D_A_196 0 2.92e-16
LD_A_196 D_A_196 D_A_197 6.4222e-10
BD_A_197 D_A_197 SDA_197 JJR area=1
CD_A_197 D_A_197 0 2.92e-16
LD_A_197 D_A_197 D_A_198 6.4222e-10
BD_A_198 D_A_198 SDA_198 JJR area=1
CD_A_198 D_A_198 0 2.92e-16
LD_A_198 D_A_198 D_A_199 6.4222e-10
BD_A_199 D_A_199 SDA_199 JJR area=1
CD_A_199 D_A_199 0 2.92e-16
LD_A_199 D_A_199 D_A_200 6.4222e-10
BD_A_200 D_A_200 SDA_200 JJR area=1
CD_A_200 D_A_200 0 2.92e-16
LD_A_200 D_A_200 D_A_201 6.4222e-10
BD_A_201 D_A_201 SDA_201 JJR area=1
CD_A_201 D_A_201 0 2.92e-16
LD_A_201 D_A_201 D_A_202 6.4222e-10
BD_A_202 D_A_202 SDA_202 JJR area=1
CD_A_202 D_A_202 0 2.92e-16
LD_A_202 D_A_202 D_A_203 6.4222e-10
BD_A_203 D_A_203 SDA_203 JJR area=1
CD_A_203 D_A_203 0 2.92e-16
LD_A_203 D_A_203 D_A_204 6.4222e-10
BD_A_204 D_A_204 SDA_204 JJR area=1
CD_A_204 D_A_204 0 2.92e-16
LD_A_204 D_A_204 D_A_205 6.4222e-10
BD_A_205 D_A_205 SDA_205 JJR area=1
CD_A_205 D_A_205 0 2.92e-16
LD_A_205 D_A_205 D_A_206 6.4222e-10
BD_A_206 D_A_206 SDA_206 JJR area=1
CD_A_206 D_A_206 0 2.92e-16
LD_A_206 D_A_206 D_A_207 6.4222e-10
BD_A_207 D_A_207 SDA_207 JJR area=1
CD_A_207 D_A_207 0 2.92e-16
LD_A_207 D_A_207 D_A_208 6.4222e-10
BD_A_208 D_A_208 SDA_208 JJR area=1
CD_A_208 D_A_208 0 2.92e-16
LD_A_208 D_A_208 D_A_209 6.4222e-10
BD_A_209 D_A_209 SDA_209 JJR area=1
CD_A_209 D_A_209 0 2.92e-16
LD_A_209 D_A_209 D_A_210 6.4222e-10
BD_A_210 D_A_210 SDA_210 JJR area=1
CD_A_210 D_A_210 0 2.92e-16
LD_A_210 D_A_210 D_A_211 6.4222e-10
BD_A_211 D_A_211 SDA_211 JJR area=1
CD_A_211 D_A_211 0 2.92e-16
LD_A_211 D_A_211 D_A_212 6.4222e-10
BD_A_212 D_A_212 SDA_212 JJR area=1
CD_A_212 D_A_212 0 2.92e-16
LD_A_212 D_A_212 D_A_213 6.4222e-10
BD_A_213 D_A_213 SDA_213 JJR area=1
CD_A_213 D_A_213 0 2.92e-16
LD_A_213 D_A_213 D_A_214 6.4222e-10
BD_A_214 D_A_214 SDA_214 JJR area=1
CD_A_214 D_A_214 0 2.92e-16
LD_A_214 D_A_214 D_A_215 6.4222e-10
BD_A_215 D_A_215 SDA_215 JJR area=1
CD_A_215 D_A_215 0 2.92e-16
LD_A_215 D_A_215 D_A_216 6.4222e-10
BD_A_216 D_A_216 SDA_216 JJR area=1
CD_A_216 D_A_216 0 2.92e-16
LD_A_216 D_A_216 D_A_217 6.4222e-10
BD_A_217 D_A_217 SDA_217 JJR area=1
CD_A_217 D_A_217 0 2.92e-16
LD_A_217 D_A_217 D_A_218 6.4222e-10
BD_A_218 D_A_218 SDA_218 JJR area=1
CD_A_218 D_A_218 0 2.92e-16
LD_A_218 D_A_218 D_A_219 6.4222e-10
BD_A_219 D_A_219 SDA_219 JJR area=1
CD_A_219 D_A_219 0 2.92e-16
LD_A_219 D_A_219 D_A_220 6.4222e-10
BD_A_220 D_A_220 SDA_220 JJR area=1
CD_A_220 D_A_220 0 2.92e-16
LD_A_220 D_A_220 D_A_221 6.4222e-10
BD_A_221 D_A_221 SDA_221 JJR area=1
CD_A_221 D_A_221 0 2.92e-16
LD_A_221 D_A_221 D_A_222 6.4222e-10
BD_A_222 D_A_222 SDA_222 JJR area=1
CD_A_222 D_A_222 0 2.92e-16
LD_A_222 D_A_222 D_A_223 6.4222e-10
BD_A_223 D_A_223 SDA_223 JJR area=1
CD_A_223 D_A_223 0 2.92e-16
LD_A_223 D_A_223 D_A_224 6.4222e-10
BD_A_224 D_A_224 SDA_224 JJR area=1
CD_A_224 D_A_224 0 2.92e-16
LD_A_224 D_A_224 D_A_225 6.4222e-10
BD_A_225 D_A_225 SDA_225 JJR area=1
CD_A_225 D_A_225 0 2.92e-16
LD_A_225 D_A_225 D_A_226 6.4222e-10
BD_A_226 D_A_226 SDA_226 JJR area=1
CD_A_226 D_A_226 0 2.92e-16
LD_A_226 D_A_226 D_A_227 6.4222e-10
BD_A_227 D_A_227 SDA_227 JJR area=1
CD_A_227 D_A_227 0 2.92e-16
LD_A_227 D_A_227 D_A_228 6.4222e-10
BD_A_228 D_A_228 SDA_228 JJR area=1
CD_A_228 D_A_228 0 2.92e-16
LD_A_228 D_A_228 D_A_229 6.4222e-10
BD_A_229 D_A_229 SDA_229 JJR area=1
CD_A_229 D_A_229 0 2.92e-16
LD_A_229 D_A_229 D_A_230 6.4222e-10
BD_A_230 D_A_230 SDA_230 JJR area=1
CD_A_230 D_A_230 0 2.92e-16
LD_A_230 D_A_230 D_A_231 6.4222e-10
BD_A_231 D_A_231 SDA_231 JJR area=1
CD_A_231 D_A_231 0 2.92e-16
LD_A_231 D_A_231 D_A_232 6.4222e-10
BD_A_232 D_A_232 SDA_232 JJR area=1
CD_A_232 D_A_232 0 2.92e-16
LD_A_232 D_A_232 D_A_233 6.4222e-10
BD_A_233 D_A_233 SDA_233 JJR area=1
CD_A_233 D_A_233 0 2.92e-16
LD_A_233 D_A_233 D_A_234 6.4222e-10
BD_A_234 D_A_234 SDA_234 JJR area=1
CD_A_234 D_A_234 0 2.92e-16
LD_A_234 D_A_234 D_A_235 6.4222e-10
BD_A_235 D_A_235 SDA_235 JJR area=1
CD_A_235 D_A_235 0 2.92e-16
LD_A_235 D_A_235 D_A_236 6.4222e-10
BD_A_236 D_A_236 SDA_236 JJR area=1
CD_A_236 D_A_236 0 2.92e-16
LD_A_236 D_A_236 D_A_237 6.4222e-10
BD_A_237 D_A_237 SDA_237 JJR area=1
CD_A_237 D_A_237 0 2.92e-16
LD_A_237 D_A_237 D_A_238 6.4222e-10
BD_A_238 D_A_238 SDA_238 JJR area=1
CD_A_238 D_A_238 0 2.92e-16
LD_A_238 D_A_238 D_A_239 6.4222e-10
BD_A_239 D_A_239 SDA_239 JJR area=1
CD_A_239 D_A_239 0 2.92e-16
LD_A_239 D_A_239 D_A_240 6.4222e-10
BD_A_240 D_A_240 SDA_240 JJR area=1
CD_A_240 D_A_240 0 2.92e-16
LD_A_240 D_A_240 D_A_241 6.4222e-10
BD_A_241 D_A_241 SDA_241 JJR area=1
CD_A_241 D_A_241 0 2.92e-16
LD_A_241 D_A_241 D_A_242 6.4222e-10
BD_A_242 D_A_242 SDA_242 JJR area=1
CD_A_242 D_A_242 0 2.92e-16
LD_A_242 D_A_242 D_A_243 6.4222e-10
BD_A_243 D_A_243 SDA_243 JJR area=1
CD_A_243 D_A_243 0 2.92e-16
LD_A_243 D_A_243 D_A_244 6.4222e-10
BD_A_244 D_A_244 SDA_244 JJR area=1
CD_A_244 D_A_244 0 2.92e-16
LD_A_244 D_A_244 D_A_245 6.4222e-10
BD_A_245 D_A_245 SDA_245 JJR area=1
CD_A_245 D_A_245 0 2.92e-16
LD_A_245 D_A_245 D_A_246 6.4222e-10
BD_A_246 D_A_246 SDA_246 JJR area=1
CD_A_246 D_A_246 0 2.92e-16
LD_A_246 D_A_246 D_A_247 6.4222e-10
BD_A_247 D_A_247 SDA_247 JJR area=1
CD_A_247 D_A_247 0 2.92e-16
LD_A_247 D_A_247 D_A_248 6.4222e-10
BD_A_248 D_A_248 SDA_248 JJR area=1
CD_A_248 D_A_248 0 2.92e-16
LD_A_248 D_A_248 D_A_249 6.4222e-10
BD_A_249 D_A_249 SDA_249 JJR area=1
CD_A_249 D_A_249 0 2.92e-16
LD_A_249 D_A_249 D_A_250 6.4222e-10
BD_A_250 D_A_250 SDA_250 JJR area=1
CD_A_250 D_A_250 0 2.92e-16
LD_A_250 D_A_250 D_A_251 6.4222e-10
BD_A_251 D_A_251 SDA_251 JJR area=1
CD_A_251 D_A_251 0 2.921e-16
LD_A_251 D_A_251 D_A_252 6.4224e-10
BD_A_252 D_A_252 SDA_252 JJR area=1
CD_A_252 D_A_252 0 2.928e-16
LD_A_252 D_A_252 D_A_253 6.423e-10
BD_A_253 D_A_253 SDA_253 JJR area=1
CD_A_253 D_A_253 0 2.941e-16
LD_A_253 D_A_253 D_A_254 6.4239e-10
BD_A_254 D_A_254 SDA_254 JJR area=1
CD_A_254 D_A_254 0 2.96e-16
LD_A_254 D_A_254 D_A_255 6.4251e-10
BD_A_255 D_A_255 SDA_255 JJR area=1
CD_A_255 D_A_255 0 2.986e-16
LD_A_255 D_A_255 D_A_256 6.4267e-10
BD_A_256 D_A_256 SDA_256 JJR area=1
CD_A_256 D_A_256 0 3.017e-16
LD_A_256 D_A_256 D_A_257 6.4286e-10
BD_A_257 D_A_257 SDA_257 JJR area=1
CD_A_257 D_A_257 0 3.055e-16
LD_A_257 D_A_257 D_A_258 6.4308e-10
BD_A_258 D_A_258 SDA_258 JJR area=1
CD_A_258 D_A_258 0 3.099e-16
LD_A_258 D_A_258 D_A_259 6.4334e-10
BD_A_259 D_A_259 SDA_259 JJR area=1
CD_A_259 D_A_259 0 3.147e-16
LD_A_259 D_A_259 D_A_260 6.4362e-10
BD_A_260 D_A_260 SDA_260 JJR area=1
CD_A_260 D_A_260 0 3.201e-16
LD_A_260 D_A_260 D_A_261 6.4393e-10
BD_A_261 D_A_261 SDA_261 JJR area=1
CD_A_261 D_A_261 0 3.26e-16
LD_A_261 D_A_261 D_A_262 6.4426e-10
BD_A_262 D_A_262 SDA_262 JJR area=1
CD_A_262 D_A_262 0 3.324e-16
LD_A_262 D_A_262 D_A_263 6.4462e-10
BD_A_263 D_A_263 SDA_263 JJR area=1
CD_A_263 D_A_263 0 3.391e-16
LD_A_263 D_A_263 D_A_264 6.45e-10
BD_A_264 D_A_264 SDA_264 JJR area=1
CD_A_264 D_A_264 0 3.462e-16
LD_A_264 D_A_264 D_A_265 6.454e-10
BD_A_265 D_A_265 SDA_265 JJR area=1
CD_A_265 D_A_265 0 3.536e-16
LD_A_265 D_A_265 D_A_266 6.4581e-10
BD_A_266 D_A_266 SDA_266 JJR area=1
CD_A_266 D_A_266 0 3.613e-16
LD_A_266 D_A_266 D_A_267 6.4624e-10
BD_A_267 D_A_267 SDA_267 JJR area=1
CD_A_267 D_A_267 0 3.692e-16
LD_A_267 D_A_267 D_A_268 6.4668e-10
BD_A_268 D_A_268 SDA_268 JJR area=1
CD_A_268 D_A_268 0 3.772e-16
LD_A_268 D_A_268 D_A_269 6.4713e-10
BD_A_269 D_A_269 SDA_269 JJR area=1
CD_A_269 D_A_269 0 3.855e-16
LD_A_269 D_A_269 D_A_270 6.4758e-10
BD_A_270 D_A_270 SDA_270 JJR area=1
CD_A_270 D_A_270 0 3.938e-16
LD_A_270 D_A_270 D_A_271 6.4803e-10
BD_A_271 D_A_271 SDA_271 JJR area=1
CD_A_271 D_A_271 0 4.021e-16
LD_A_271 D_A_271 D_A_272 6.4849e-10
BD_A_272 D_A_272 SDA_272 JJR area=1
CD_A_272 D_A_272 0 4.104e-16
LD_A_272 D_A_272 D_A_273 6.4894e-10
BD_A_273 D_A_273 SDA_273 JJR area=1
CD_A_273 D_A_273 0 4.186e-16
LD_A_273 D_A_273 D_A_274 6.4939e-10
BD_A_274 D_A_274 SDA_274 JJR area=1
CD_A_274 D_A_274 0 4.267e-16
LD_A_274 D_A_274 D_A_275 6.4983e-10
BD_A_275 D_A_275 SDA_275 JJR area=1
CD_A_275 D_A_275 0 4.346e-16
LD_A_275 D_A_275 D_A_276 6.5026e-10
BD_A_276 D_A_276 SDA_276 JJR area=1
CD_A_276 D_A_276 0 4.422e-16
LD_A_276 D_A_276 D_A_277 6.5067e-10
BD_A_277 D_A_277 SDA_277 JJR area=1
CD_A_277 D_A_277 0 4.496e-16
LD_A_277 D_A_277 D_A_278 6.5107e-10
BD_A_278 D_A_278 SDA_278 JJR area=1
CD_A_278 D_A_278 0 4.567e-16
LD_A_278 D_A_278 D_A_279 6.5145e-10
BD_A_279 D_A_279 SDA_279 JJR area=1
CD_A_279 D_A_279 0 4.635e-16
LD_A_279 D_A_279 D_A_280 6.5181e-10
BD_A_280 D_A_280 SDA_280 JJR area=1
CD_A_280 D_A_280 0 4.698e-16
LD_A_280 D_A_280 D_A_281 6.5214e-10
BD_A_281 D_A_281 SDA_281 JJR area=1
CD_A_281 D_A_281 0 4.757e-16
LD_A_281 D_A_281 D_A_282 6.5245e-10
BD_A_282 D_A_282 SDA_282 JJR area=1
CD_A_282 D_A_282 0 4.811e-16
LD_A_282 D_A_282 D_A_283 6.5273e-10
BD_A_283 D_A_283 SDA_283 JJR area=1
CD_A_283 D_A_283 0 4.86e-16
LD_A_283 D_A_283 D_A_284 6.5299e-10
BD_A_284 D_A_284 SDA_284 JJR area=1
CD_A_284 D_A_284 0 4.903e-16
LD_A_284 D_A_284 D_A_285 6.5321e-10
BD_A_285 D_A_285 SDA_285 JJR area=1
CD_A_285 D_A_285 0 4.941e-16
LD_A_285 D_A_285 D_A_286 6.534e-10
BD_A_286 D_A_286 SDA_286 JJR area=1
CD_A_286 D_A_286 0 4.973e-16
LD_A_286 D_A_286 D_A_287 6.5356e-10
BD_A_287 D_A_287 SDA_287 JJR area=1
CD_A_287 D_A_287 0 4.998e-16
LD_A_287 D_A_287 D_A_288 6.5368e-10
BD_A_288 D_A_288 SDA_288 JJR area=1
CD_A_288 D_A_288 0 5.018e-16
LD_A_288 D_A_288 D_A_289 6.5377e-10
BD_A_289 D_A_289 SDA_289 JJR area=1
CD_A_289 D_A_289 0 5.031e-16
LD_A_289 D_A_289 D_A_290 6.5382e-10
BD_A_290 D_A_290 SDA_290 JJR area=1
CD_A_290 D_A_290 0 5.037e-16
LD_A_290 D_A_290 D_A_291 6.5384e-10
BD_A_291 D_A_291 0 JJR area=1
CD_A_291 D_A_291 0 5.038e-16
LD_A_291 D_A_291 D_A_292 6.5385e-10
BD_A_292 D_A_292 0 JJR area=1
CD_A_292 D_A_292 0 5.038e-16
LD_A_292 D_A_292 D_A_293 6.5385e-10
BD_A_293 D_A_293 0 JJR area=1
CD_A_293 D_A_293 0 5.038e-16
LD_A_293 D_A_293 D_A_294 6.5385e-10
BD_A_294 D_A_294 0 JJR area=1
CD_A_294 D_A_294 0 5.038e-16
LD_A_294 D_A_294 D_A_295 6.5385e-10
BD_A_295 D_A_295 0 JJR area=1
CD_A_295 D_A_295 0 5.038e-16
LD_A_295 D_A_295 D_A_296 6.5385e-10
BD_A_296 D_A_296 0 JJR area=1
CD_A_296 D_A_296 0 5.038e-16
LD_A_296 D_A_296 D_A_297 6.5385e-10
BD_A_297 D_A_297 0 JJR area=1
CD_A_297 D_A_297 0 5.038e-16
LD_A_297 D_A_297 D_A_298 6.5385e-10
BD_A_298 D_A_298 0 JJR area=1
CD_A_298 D_A_298 0 5.038e-16
LD_A_298 D_A_298 D_A_299 6.5385e-10
BD_A_299 D_A_299 0 JJR area=1
CD_A_299 D_A_299 0 5.038e-16
LD_A_299 D_A_299 D_A_300 6.5385e-10
BD_A_300 D_A_300 0 JJR area=1
CD_A_300 D_A_300 0 5.038e-16
LD_A_300 D_A_300 D_A_301 6.5385e-10
BD_A_301 D_A_301 0 JJR area=1
CD_A_301 D_A_301 0 5.038e-16
LD_A_301 D_A_301 D_A_302 6.5385e-10
BD_A_302 D_A_302 0 JJR area=1
CD_A_302 D_A_302 0 5.038e-16
LD_A_302 D_A_302 D_A_303 6.5385e-10
BD_A_303 D_A_303 0 JJR area=1
CD_A_303 D_A_303 0 5.038e-16
LD_A_303 D_A_303 D_A_304 6.5385e-10
BD_A_304 D_A_304 0 JJR area=1
CD_A_304 D_A_304 0 5.038e-16
LD_A_304 D_A_304 D_A_305 6.5385e-10
BD_A_305 D_A_305 0 JJR area=1
CD_A_305 D_A_305 0 5.038e-16
LD_A_305 D_A_305 D_A_306 6.5385e-10
BD_A_306 D_A_306 0 JJR area=1
CD_A_306 D_A_306 0 5.038e-16
LD_A_306 D_A_306 D_A_307 6.5385e-10
BD_A_307 D_A_307 0 JJR area=1
CD_A_307 D_A_307 0 5.038e-16
LD_A_307 D_A_307 D_A_308 6.5385e-10
BD_A_308 D_A_308 0 JJR area=1
CD_A_308 D_A_308 0 5.038e-16
LD_A_308 D_A_308 D_A_309 6.5385e-10
BD_A_309 D_A_309 0 JJR area=1
CD_A_309 D_A_309 0 5.038e-16
LD_A_309 D_A_309 D_A_310 6.5385e-10
BD_A_310 D_A_310 0 JJR area=1
CD_A_310 D_A_310 0 5.038e-16
LD_A_310 D_A_310 D_A_311 6.5385e-10
BD_A_311 D_A_311 0 JJR area=1
CD_A_311 D_A_311 0 5.038e-16
LD_A_311 D_A_311 D_A_312 6.5385e-10
BD_A_312 D_A_312 0 JJR area=1
CD_A_312 D_A_312 0 5.038e-16
LD_A_312 D_A_312 D_A_313 6.5385e-10
BD_A_313 D_A_313 0 JJR area=1
CD_A_313 D_A_313 0 5.038e-16
LD_A_313 D_A_313 D_A_314 6.5385e-10
BD_A_314 D_A_314 0 JJR area=1
CD_A_314 D_A_314 0 5.038e-16
LD_A_314 D_A_314 D_A_315 6.5385e-10
BD_A_315 D_A_315 0 JJR area=1
CD_A_315 D_A_315 0 5.038e-16
LD_A_315 D_A_315 D_A_316 6.5385e-10
BD_A_316 D_A_316 0 JJR area=1
CD_A_316 D_A_316 0 5.038e-16
LD_A_316 D_A_316 D_A_317 6.5385e-10
BD_A_317 D_A_317 0 JJR area=1
CD_A_317 D_A_317 0 5.038e-16
LD_A_317 D_A_317 D_A_318 6.5385e-10
BD_A_318 D_A_318 0 JJR area=1
CD_A_318 D_A_318 0 5.038e-16
LD_A_318 D_A_318 D_A_319 6.5385e-10
BD_A_319 D_A_319 0 JJR area=1
CD_A_319 D_A_319 0 5.038e-16
LD_A_319 D_A_319 D_A_320 6.5385e-10
BD_A_320 D_A_320 0 JJR area=1
CD_A_320 D_A_320 0 5.038e-16
LD_A_320 D_A_320 D_A_321 6.5385e-10
BD_A_321 D_A_321 0 JJR area=1
CD_A_321 D_A_321 0 5.038e-16
LD_A_321 D_A_321 D_A_322 6.5385e-10
BD_A_322 D_A_322 0 JJR area=1
CD_A_322 D_A_322 0 5.038e-16
LD_A_322 D_A_322 D_A_323 6.5385e-10
BD_A_323 D_A_323 0 JJR area=1
CD_A_323 D_A_323 0 5.038e-16
LD_A_323 D_A_323 D_A_324 6.5385e-10
BD_A_324 D_A_324 0 JJR area=1
CD_A_324 D_A_324 0 5.038e-16
LD_A_324 D_A_324 D_A_325 6.5385e-10
BD_A_325 D_A_325 0 JJR area=1
CD_A_325 D_A_325 0 5.038e-16
LD_A_325 D_A_325 D_A_326 6.5385e-10
BD_A_326 D_A_326 0 JJR area=1
CD_A_326 D_A_326 0 5.038e-16
LD_A_326 D_A_326 D_A_327 6.5385e-10
BD_A_327 D_A_327 0 JJR area=1
CD_A_327 D_A_327 0 5.038e-16
LD_A_327 D_A_327 D_A_328 6.5385e-10
BD_A_328 D_A_328 0 JJR area=1
CD_A_328 D_A_328 0 5.038e-16
LD_A_328 D_A_328 D_A_329 6.5385e-10
BD_A_329 D_A_329 0 JJR area=1
CD_A_329 D_A_329 0 5.038e-16
LD_A_329 D_A_329 D_A_330 6.5385e-10
BD_A_330 D_A_330 0 JJR area=1
CD_A_330 D_A_330 0 5.038e-16
LD_A_330 D_A_330 D_A_331 6.5385e-10
BD_A_331 D_A_331 0 JJR area=1
CD_A_331 D_A_331 0 5.038e-16
LD_A_331 D_A_331 D_A_332 6.5385e-10
BD_A_332 D_A_332 0 JJR area=1
CD_A_332 D_A_332 0 5.038e-16
LD_A_332 D_A_332 D_A_333 6.5385e-10
BD_A_333 D_A_333 0 JJR area=1
CD_A_333 D_A_333 0 5.038e-16
LD_A_333 D_A_333 D_A_334 6.5385e-10
BD_A_334 D_A_334 0 JJR area=1
CD_A_334 D_A_334 0 5.038e-16
LD_A_334 D_A_334 D_A_335 6.5385e-10
BD_A_335 D_A_335 0 JJR area=1
CD_A_335 D_A_335 0 5.038e-16
LD_A_335 D_A_335 D_A_336 6.5385e-10
BD_A_336 D_A_336 0 JJR area=1
CD_A_336 D_A_336 0 5.038e-16
LD_A_336 D_A_336 D_A_337 6.5385e-10
BD_A_337 D_A_337 0 JJR area=1
CD_A_337 D_A_337 0 5.038e-16
LD_A_337 D_A_337 D_A_338 6.5385e-10
BD_A_338 D_A_338 0 JJR area=1
CD_A_338 D_A_338 0 5.038e-16
LD_A_338 D_A_338 D_A_339 6.5385e-10
BD_A_339 D_A_339 0 JJR area=1
CD_A_339 D_A_339 0 5.038e-16
LD_A_339 D_A_339 D_A_340 6.5385e-10
BD_A_340 D_A_340 0 JJR area=1
CD_A_340 D_A_340 0 5.038e-16
LD_A_340 D_A_340 D_A_341 6.5385e-10
BD_A_341 D_A_341 0 JJR area=1
CD_A_341 D_A_341 0 5.038e-16
LD_A_341 D_A_341 D_A_342 6.5385e-10
BD_A_342 D_A_342 0 JJR area=1
CD_A_342 D_A_342 0 5.038e-16
LD_A_342 D_A_342 D_A_343 6.5385e-10
BD_A_343 D_A_343 0 JJR area=1
CD_A_343 D_A_343 0 5.038e-16
LD_A_343 D_A_343 D_A_344 6.5385e-10
BD_A_344 D_A_344 0 JJR area=1
CD_A_344 D_A_344 0 5.038e-16
LD_A_344 D_A_344 D_A_345 6.5385e-10
BD_A_345 D_A_345 0 JJR area=1
CD_A_345 D_A_345 0 5.038e-16
LD_A_345 D_A_345 D_A_346 6.5385e-10
BD_A_346 D_A_346 0 JJR area=1
CD_A_346 D_A_346 0 5.038e-16
LD_A_346 D_A_346 D_A_347 6.5385e-10
BD_A_347 D_A_347 0 JJR area=1
CD_A_347 D_A_347 0 5.038e-16
LD_A_347 D_A_347 D_A_348 6.5385e-10
BD_A_348 D_A_348 0 JJR area=1
CD_A_348 D_A_348 0 5.038e-16
LD_A_348 D_A_348 D_A_349 6.5385e-10
BD_A_349 D_A_349 0 JJR area=1
CD_A_349 D_A_349 0 5.038e-16
LD_A_349 D_A_349 D_A_350 6.5385e-10
BD_A_350 D_A_350 0 JJR area=1
CD_A_350 D_A_350 0 5.038e-16
LD_A_350 D_A_350 D_A_351 6.5385e-10
BD_A_351 D_A_351 0 JJR area=1
CD_A_351 D_A_351 0 5.038e-16
LD_A_351 D_A_351 D_A_352 6.5385e-10
BD_A_352 D_A_352 0 JJR area=1
CD_A_352 D_A_352 0 5.038e-16
LD_A_352 D_A_352 D_A_353 6.5385e-10
BD_A_353 D_A_353 0 JJR area=1
CD_A_353 D_A_353 0 5.038e-16
LD_A_353 D_A_353 D_A_354 6.5385e-10
BD_A_354 D_A_354 0 JJR area=1
CD_A_354 D_A_354 0 5.038e-16
LD_A_354 D_A_354 D_A_355 6.5385e-10
BD_A_355 D_A_355 0 JJR area=1
CD_A_355 D_A_355 0 5.038e-16
LD_A_355 D_A_355 D_A_356 6.5385e-10
BD_A_356 D_A_356 0 JJR area=1
CD_A_356 D_A_356 0 5.038e-16
LD_A_356 D_A_356 D_A_357 6.5385e-10
BD_A_357 D_A_357 0 JJR area=1
CD_A_357 D_A_357 0 5.038e-16
LD_A_357 D_A_357 D_A_358 6.5385e-10
BD_A_358 D_A_358 0 JJR area=1
CD_A_358 D_A_358 0 5.038e-16
LD_A_358 D_A_358 D_A_359 6.5385e-10
BD_A_359 D_A_359 0 JJR area=1
CD_A_359 D_A_359 0 5.038e-16
LD_A_359 D_A_359 D_A_360 6.5385e-10
BD_A_360 D_A_360 0 JJR area=1
CD_A_360 D_A_360 0 5.038e-16
LD_A_360 D_A_360 D_A_361 6.5385e-10
BD_A_361 D_A_361 0 JJR area=1
CD_A_361 D_A_361 0 5.038e-16
BA0_0 A0_0 0 JJR area=1
CA0_0 A0_0 0 5.038e-16
LA0_0 A0_0 A0_1 6.5385e-10
BA0_1 A0_1 0 JJR area=1
CA0_1 A0_1 0 5.038e-16
LA0_1 A0_1 A0_2 6.5385e-10
BA0_2 A0_2 0 JJR area=1
CA0_2 A0_2 0 5.038e-16
LA0_2 A0_2 A0_3 6.5385e-10
BA0_3 A0_3 0 JJR area=1
CA0_3 A0_3 0 5.038e-16
LA0_3 A0_3 A0_4 6.5385e-10
BA0_4 A0_4 0 JJR area=1
CA0_4 A0_4 0 5.038e-16
LA0_4 A0_4 A0_5 6.5385e-10
BA0_5 A0_5 0 JJR area=1
CA0_5 A0_5 0 5.038e-16
LA0_5 A0_5 A0_6 6.5385e-10
BA0_6 A0_6 0 JJR area=1
CA0_6 A0_6 0 5.038e-16
LA0_6 A0_6 A0_7 6.5385e-10
BA0_7 A0_7 0 JJR area=1
CA0_7 A0_7 0 5.038e-16
LA0_7 A0_7 A0_8 6.5385e-10
BA0_8 A0_8 0 JJR area=1
CA0_8 A0_8 0 5.038e-16
LA0_8 A0_8 A0_9 6.5385e-10
BA0_9 A0_9 0 JJR area=1
CA0_9 A0_9 0 5.038e-16
LA0_9 A0_9 A0_10 6.5385e-10
BA0_10 A0_10 0 JJR area=1
CA0_10 A0_10 0 5.038e-16
LA0_10 A0_10 A0_11 6.5385e-10
BA0_11 A0_11 0 JJR area=1
CA0_11 A0_11 0 5.038e-16
LA0_11 A0_11 A0_12 6.5385e-10
BA0_12 A0_12 0 JJR area=1
CA0_12 A0_12 0 5.038e-16
LA0_12 A0_12 A0_13 6.5385e-10
BA0_13 A0_13 0 JJR area=1
CA0_13 A0_13 0 5.038e-16
LA0_13 A0_13 A0_14 6.5385e-10
BA0_14 A0_14 0 JJR area=1
CA0_14 A0_14 0 5.038e-16
LA0_14 A0_14 A0_15 6.5385e-10
BA0_15 A0_15 0 JJR area=1
CA0_15 A0_15 0 5.038e-16
LA0_15 A0_15 A0_16 6.5385e-10
BA0_16 A0_16 0 JJR area=1
CA0_16 A0_16 0 5.038e-16
LA0_16 A0_16 A0_17 6.5385e-10
BA0_17 A0_17 0 JJR area=1
CA0_17 A0_17 0 5.038e-16
LA0_17 A0_17 A0_18 6.5385e-10
BA0_18 A0_18 0 JJR area=1
CA0_18 A0_18 0 5.038e-16
LA0_18 A0_18 A0_19 6.5385e-10
BA0_19 A0_19 0 JJR area=1
CA0_19 A0_19 0 5.038e-16
LA0_19 A0_19 A0_20 6.5385e-10
BA0_20 A0_20 0 JJR area=1
CA0_20 A0_20 0 5.038e-16
LA0_20 A0_20 A0_21 6.5385e-10
BA0_21 A0_21 0 JJR area=1
CA0_21 A0_21 0 5.038e-16
LA0_21 A0_21 A0_22 6.5385e-10
BA0_22 A0_22 0 JJR area=1
CA0_22 A0_22 0 5.038e-16
LA0_22 A0_22 A0_23 6.5385e-10
BA0_23 A0_23 0 JJR area=1
CA0_23 A0_23 0 5.038e-16
LA0_23 A0_23 A0_24 6.5385e-10
BA0_24 A0_24 0 JJR area=1
CA0_24 A0_24 0 5.038e-16
LA0_24 A0_24 A0_25 6.5385e-10
BA0_25 A0_25 0 JJR area=1
CA0_25 A0_25 0 5.038e-16
LA0_25 A0_25 A0_26 6.5385e-10
BA0_26 A0_26 0 JJR area=1
CA0_26 A0_26 0 5.038e-16
LA0_26 A0_26 A0_27 6.5385e-10
BA0_27 A0_27 0 JJR area=1
CA0_27 A0_27 0 5.038e-16
LA0_27 A0_27 A0_28 6.5385e-10
BA0_28 A0_28 0 JJR area=1
CA0_28 A0_28 0 5.038e-16
LA0_28 A0_28 A0_29 6.5385e-10
BA0_29 A0_29 0 JJR area=1
CA0_29 A0_29 0 5.038e-16
LA0_29 A0_29 A0_30 6.5385e-10
BA0_30 A0_30 0 JJR area=1
CA0_30 A0_30 0 5.038e-16
LA0_30 A0_30 A0_31 6.5385e-10
BA0_31 A0_31 0 JJR area=1
CA0_31 A0_31 0 5.038e-16
LA0_31 A0_31 A0_32 6.5385e-10
BA0_32 A0_32 0 JJR area=1
CA0_32 A0_32 0 5.038e-16
LA0_32 A0_32 A0_33 6.5385e-10
BA0_33 A0_33 0 JJR area=1
CA0_33 A0_33 0 5.038e-16
LA0_33 A0_33 A0_34 6.5385e-10
BA0_34 A0_34 0 JJR area=1
CA0_34 A0_34 0 5.038e-16
LA0_34 A0_34 A0_35 6.5385e-10
BA0_35 A0_35 0 JJR area=1
CA0_35 A0_35 0 5.038e-16
LA0_35 A0_35 A0_36 6.5385e-10
BA0_36 A0_36 0 JJR area=1
CA0_36 A0_36 0 5.038e-16
LA0_36 A0_36 A0_37 6.5385e-10
BA0_37 A0_37 0 JJR area=1
CA0_37 A0_37 0 5.038e-16
LA0_37 A0_37 A0_38 6.5385e-10
BA0_38 A0_38 0 JJR area=1
CA0_38 A0_38 0 5.038e-16
LA0_38 A0_38 A0_39 6.5385e-10
BA0_39 A0_39 0 JJR area=1
CA0_39 A0_39 0 5.038e-16
LA0_39 A0_39 A0_40 6.5385e-10
BA0_40 A0_40 0 JJR area=1
CA0_40 A0_40 0 5.038e-16
LA0_40 A0_40 A0_41 6.5385e-10
BA0_41 A0_41 0 JJR area=1
CA0_41 A0_41 0 5.038e-16
LA0_41 A0_41 A0_42 6.5385e-10
BA0_42 A0_42 0 JJR area=1
CA0_42 A0_42 0 5.038e-16
LA0_42 A0_42 A0_43 6.5385e-10
BA0_43 A0_43 0 JJR area=1
CA0_43 A0_43 0 5.038e-16
LA0_43 A0_43 A0_44 6.5385e-10
BA0_44 A0_44 0 JJR area=1
CA0_44 A0_44 0 5.038e-16
LA0_44 A0_44 A0_45 6.5385e-10
BA0_45 A0_45 0 JJR area=1
CA0_45 A0_45 0 5.038e-16
LA0_45 A0_45 A0_46 6.5385e-10
BA0_46 A0_46 0 JJR area=1
CA0_46 A0_46 0 5.038e-16
LA0_46 A0_46 A0_47 6.5385e-10
BA0_47 A0_47 0 JJR area=1
CA0_47 A0_47 0 5.038e-16
LA0_47 A0_47 A0_48 6.5385e-10
BA0_48 A0_48 0 JJR area=1
CA0_48 A0_48 0 5.038e-16
LA0_48 A0_48 A0_49 6.5385e-10
BA0_49 A0_49 0 JJR area=1
CA0_49 A0_49 0 5.038e-16
LA0_49 A0_49 A0_50 6.5385e-10
BA0_50 A0_50 MA_50 JJR area=1
CA0_50 A0_50 0 5.038e-16
LA0_50 A0_50 A0_51 6.5385e-10
BA0_51 A0_51 MA_51 JJR area=1
CA0_51 A0_51 0 5.038e-16
LA0_51 A0_51 A0_52 6.5385e-10
BA0_52 A0_52 MA_52 JJR area=1
CA0_52 A0_52 0 5.038e-16
LA0_52 A0_52 A0_53 6.5385e-10
BA0_53 A0_53 MA_53 JJR area=1
CA0_53 A0_53 0 5.038e-16
LA0_53 A0_53 A0_54 6.5385e-10
BA0_54 A0_54 MA_54 JJR area=1
CA0_54 A0_54 0 5.038e-16
LA0_54 A0_54 A0_55 6.5385e-10
BA0_55 A0_55 MA_55 JJR area=1
CA0_55 A0_55 0 5.038e-16
LA0_55 A0_55 A0_56 6.5385e-10
BA0_56 A0_56 MA_56 JJR area=1
CA0_56 A0_56 0 5.038e-16
LA0_56 A0_56 A0_57 6.5385e-10
BA0_57 A0_57 MA_57 JJR area=1
CA0_57 A0_57 0 5.038e-16
LA0_57 A0_57 A0_58 6.5385e-10
BA0_58 A0_58 MA_58 JJR area=1
CA0_58 A0_58 0 5.038e-16
LA0_58 A0_58 A0_59 6.5385e-10
BA0_59 A0_59 MA_59 JJR area=1
CA0_59 A0_59 0 5.038e-16
LA0_59 A0_59 A0_60 6.5385e-10
BA0_60 A0_60 MA_60 JJR area=1
CA0_60 A0_60 0 5.038e-16
LA0_60 A0_60 A0_61 6.5385e-10
BA0_61 A0_61 MA_61 JJR area=1
CA0_61 A0_61 0 5.038e-16
LA0_61 A0_61 A0_62 6.5385e-10
BA0_62 A0_62 MA_62 JJR area=1
CA0_62 A0_62 0 5.038e-16
LA0_62 A0_62 A0_63 6.5385e-10
BA0_63 A0_63 MA_63 JJR area=1
CA0_63 A0_63 0 5.038e-16
LA0_63 A0_63 A0_64 6.5385e-10
BA0_64 A0_64 MA_64 JJR area=1
CA0_64 A0_64 0 5.038e-16
LA0_64 A0_64 A0_65 6.5385e-10
BA0_65 A0_65 MA_65 JJR area=1
CA0_65 A0_65 0 5.038e-16
LA0_65 A0_65 A0_66 6.5385e-10
BA0_66 A0_66 MA_66 JJR area=1
CA0_66 A0_66 0 5.038e-16
LA0_66 A0_66 A0_67 6.5385e-10
BA0_67 A0_67 MA_67 JJR area=1
CA0_67 A0_67 0 5.038e-16
LA0_67 A0_67 A0_68 6.5385e-10
BA0_68 A0_68 MA_68 JJR area=1
CA0_68 A0_68 0 5.038e-16
LA0_68 A0_68 A0_69 6.5385e-10
BA0_69 A0_69 MA_69 JJR area=1
CA0_69 A0_69 0 5.038e-16
LA0_69 A0_69 A0_70 6.5385e-10
BA0_70 A0_70 MA_70 JJR area=1
CA0_70 A0_70 0 5.038e-16
LA0_70 A0_70 A0_71 6.5385e-10
BA0_71 A0_71 MA_71 JJR area=1
CA0_71 A0_71 0 5.038e-16
LA0_71 A0_71 A0_72 6.5385e-10
BA0_72 A0_72 MA_72 JJR area=1
CA0_72 A0_72 0 5.038e-16
LA0_72 A0_72 A0_73 6.5385e-10
BA0_73 A0_73 MA_73 JJR area=1
CA0_73 A0_73 0 5.038e-16
LA0_73 A0_73 A0_74 6.5385e-10
BA0_74 A0_74 MA_74 JJR area=1
CA0_74 A0_74 0 5.038e-16
LA0_74 A0_74 A0_75 6.5385e-10
BA0_75 A0_75 MA_75 JJR area=1
CA0_75 A0_75 0 5.038e-16
LA0_75 A0_75 A0_76 6.5385e-10
BA0_76 A0_76 MA_76 JJR area=1
CA0_76 A0_76 0 5.038e-16
LA0_76 A0_76 A0_77 6.5385e-10
BA0_77 A0_77 MA_77 JJR area=1
CA0_77 A0_77 0 5.038e-16
LA0_77 A0_77 A0_78 6.5385e-10
BA0_78 A0_78 MA_78 JJR area=1
CA0_78 A0_78 0 5.038e-16
LA0_78 A0_78 A0_79 6.5385e-10
BA0_79 A0_79 MA_79 JJR area=1
CA0_79 A0_79 0 5.038e-16
LA0_79 A0_79 A0_80 6.5385e-10
BA0_80 A0_80 MA_80 JJR area=1
CA0_80 A0_80 0 5.038e-16
LA0_80 A0_80 A0_81 6.5385e-10
BA0_81 A0_81 MA_81 JJR area=1
CA0_81 A0_81 0 5.038e-16
LA0_81 A0_81 A0_82 6.5385e-10
BA0_82 A0_82 MA_82 JJR area=1
CA0_82 A0_82 0 5.038e-16
LA0_82 A0_82 A0_83 6.5385e-10
BA0_83 A0_83 MA_83 JJR area=1
CA0_83 A0_83 0 5.038e-16
LA0_83 A0_83 A0_84 6.5385e-10
BA0_84 A0_84 MA_84 JJR area=1
CA0_84 A0_84 0 5.038e-16
LA0_84 A0_84 A0_85 6.5385e-10
BA0_85 A0_85 MA_85 JJR area=1
CA0_85 A0_85 0 5.038e-16
LA0_85 A0_85 A0_86 6.5385e-10
BA0_86 A0_86 MA_86 JJR area=1
CA0_86 A0_86 0 5.038e-16
LA0_86 A0_86 A0_87 6.5385e-10
BA0_87 A0_87 MA_87 JJR area=1
CA0_87 A0_87 0 5.038e-16
LA0_87 A0_87 A0_88 6.5385e-10
BA0_88 A0_88 MA_88 JJR area=1
CA0_88 A0_88 0 5.038e-16
LA0_88 A0_88 A0_89 6.5385e-10
BA0_89 A0_89 MA_89 JJR area=1
CA0_89 A0_89 0 5.038e-16
LA0_89 A0_89 A0_90 6.5385e-10
BA0_90 A0_90 MA_90 JJR area=1
CA0_90 A0_90 0 5.038e-16
LA0_90 A0_90 A0_91 6.5385e-10
BA0_91 A0_91 0 JJR area=1
CA0_91 A0_91 0 5.038e-16
LA0_91 A0_91 A0_92 6.5385e-10
BA0_92 A0_92 0 JJR area=1
CA0_92 A0_92 0 5.038e-16
LA0_92 A0_92 A0_93 6.5385e-10
BA0_93 A0_93 0 JJR area=1
CA0_93 A0_93 0 5.038e-16
LA0_93 A0_93 A0_94 6.5385e-10
BA0_94 A0_94 0 JJR area=1
CA0_94 A0_94 0 5.038e-16
LA0_94 A0_94 A0_95 6.5385e-10
BA0_95 A0_95 0 JJR area=1
CA0_95 A0_95 0 5.038e-16
LA0_95 A0_95 A0_96 6.5385e-10
BA0_96 A0_96 0 JJR area=1
CA0_96 A0_96 0 5.038e-16
LA0_96 A0_96 A0_97 6.5385e-10
BA0_97 A0_97 0 JJR area=1
CA0_97 A0_97 0 5.038e-16
LA0_97 A0_97 A0_98 6.5385e-10
BA0_98 A0_98 0 JJR area=1
CA0_98 A0_98 0 5.038e-16
LA0_98 A0_98 A0_99 6.5385e-10
BA0_99 A0_99 0 JJR area=1
CA0_99 A0_99 0 5.038e-16
LA0_99 A0_99 A0_100 6.5385e-10
BA0_100 A0_100 0 JJR area=1
CA0_100 A0_100 0 5.038e-16
LA0_100 A0_100 A0_101 6.5385e-10
BA0_101 A0_101 0 JJR area=1
CA0_101 A0_101 0 5.038e-16
LA0_101 A0_101 A0_102 6.5385e-10
BA0_102 A0_102 0 JJR area=1
CA0_102 A0_102 0 5.038e-16
LA0_102 A0_102 A0_103 6.5385e-10
BA0_103 A0_103 0 JJR area=1
CA0_103 A0_103 0 5.038e-16
LA0_103 A0_103 A0_104 6.5385e-10
BA0_104 A0_104 0 JJR area=1
CA0_104 A0_104 0 5.038e-16
LA0_104 A0_104 A0_105 6.5385e-10
BA0_105 A0_105 0 JJR area=1
CA0_105 A0_105 0 5.038e-16
LA0_105 A0_105 A0_106 6.5385e-10
BA0_106 A0_106 0 JJR area=1
CA0_106 A0_106 0 5.038e-16
LA0_106 A0_106 A0_107 6.5385e-10
BA0_107 A0_107 0 JJR area=1
CA0_107 A0_107 0 5.038e-16
LA0_107 A0_107 A0_108 6.5385e-10
BA0_108 A0_108 0 JJR area=1
CA0_108 A0_108 0 5.038e-16
LA0_108 A0_108 A0_109 6.5385e-10
BA0_109 A0_109 0 JJR area=1
CA0_109 A0_109 0 5.038e-16
LA0_109 A0_109 A0_110 6.5385e-10
BA0_110 A0_110 0 JJR area=1
CA0_110 A0_110 0 5.038e-16
LA0_110 A0_110 A0_111 6.5384e-10
BA0_111 A0_111 SDA_111 JJR area=1
CA0_111 A0_111 0 5.037e-16
LA0_111 A0_111 A0_112 6.5382e-10
BA0_112 A0_112 SDA_112 JJR area=1
CA0_112 A0_112 0 5.031e-16
LA0_112 A0_112 A0_113 6.5377e-10
BA0_113 A0_113 SDA_113 JJR area=1
CA0_113 A0_113 0 5.018e-16
LA0_113 A0_113 A0_114 6.5368e-10
BA0_114 A0_114 SDA_114 JJR area=1
CA0_114 A0_114 0 4.998e-16
LA0_114 A0_114 A0_115 6.5356e-10
BA0_115 A0_115 SDA_115 JJR area=1
CA0_115 A0_115 0 4.973e-16
LA0_115 A0_115 A0_116 6.534e-10
BA0_116 A0_116 SDA_116 JJR area=1
CA0_116 A0_116 0 4.941e-16
LA0_116 A0_116 A0_117 6.5321e-10
BA0_117 A0_117 SDA_117 JJR area=1
CA0_117 A0_117 0 4.903e-16
LA0_117 A0_117 A0_118 6.5299e-10
BA0_118 A0_118 SDA_118 JJR area=1
CA0_118 A0_118 0 4.86e-16
LA0_118 A0_118 A0_119 6.5273e-10
BA0_119 A0_119 SDA_119 JJR area=1
CA0_119 A0_119 0 4.811e-16
LA0_119 A0_119 A0_120 6.5245e-10
BA0_120 A0_120 SDA_120 JJR area=1
CA0_120 A0_120 0 4.757e-16
LA0_120 A0_120 A0_121 6.5214e-10
BA0_121 A0_121 SDA_121 JJR area=1
CA0_121 A0_121 0 4.698e-16
LA0_121 A0_121 A0_122 6.5181e-10
BA0_122 A0_122 SDA_122 JJR area=1
CA0_122 A0_122 0 4.635e-16
LA0_122 A0_122 A0_123 6.5145e-10
BA0_123 A0_123 SDA_123 JJR area=1
CA0_123 A0_123 0 4.567e-16
LA0_123 A0_123 A0_124 6.5107e-10
BA0_124 A0_124 SDA_124 JJR area=1
CA0_124 A0_124 0 4.496e-16
LA0_124 A0_124 A0_125 6.5067e-10
BA0_125 A0_125 SDA_125 JJR area=1
CA0_125 A0_125 0 4.422e-16
LA0_125 A0_125 A0_126 6.5026e-10
BA0_126 A0_126 SDA_126 JJR area=1
CA0_126 A0_126 0 4.346e-16
LA0_126 A0_126 A0_127 6.4983e-10
BA0_127 A0_127 SDA_127 JJR area=1
CA0_127 A0_127 0 4.267e-16
LA0_127 A0_127 A0_128 6.4939e-10
BA0_128 A0_128 SDA_128 JJR area=1
CA0_128 A0_128 0 4.186e-16
LA0_128 A0_128 A0_129 6.4894e-10
BA0_129 A0_129 SDA_129 JJR area=1
CA0_129 A0_129 0 4.104e-16
LA0_129 A0_129 A0_130 6.4849e-10
BA0_130 A0_130 SDA_130 JJR area=1
CA0_130 A0_130 0 4.021e-16
LA0_130 A0_130 A0_131 6.4803e-10
BA0_131 A0_131 SDA_131 JJR area=1
CA0_131 A0_131 0 3.938e-16
LA0_131 A0_131 A0_132 6.4758e-10
BA0_132 A0_132 SDA_132 JJR area=1
CA0_132 A0_132 0 3.855e-16
LA0_132 A0_132 A0_133 6.4713e-10
BA0_133 A0_133 SDA_133 JJR area=1
CA0_133 A0_133 0 3.772e-16
LA0_133 A0_133 A0_134 6.4668e-10
BA0_134 A0_134 SDA_134 JJR area=1
CA0_134 A0_134 0 3.692e-16
LA0_134 A0_134 A0_135 6.4624e-10
BA0_135 A0_135 SDA_135 JJR area=1
CA0_135 A0_135 0 3.613e-16
LA0_135 A0_135 A0_136 6.4581e-10
BA0_136 A0_136 SDA_136 JJR area=1
CA0_136 A0_136 0 3.536e-16
LA0_136 A0_136 A0_137 6.454e-10
BA0_137 A0_137 SDA_137 JJR area=1
CA0_137 A0_137 0 3.462e-16
LA0_137 A0_137 A0_138 6.45e-10
BA0_138 A0_138 SDA_138 JJR area=1
CA0_138 A0_138 0 3.391e-16
LA0_138 A0_138 A0_139 6.4462e-10
BA0_139 A0_139 SDA_139 JJR area=1
CA0_139 A0_139 0 3.324e-16
LA0_139 A0_139 A0_140 6.4426e-10
BA0_140 A0_140 SDA_140 JJR area=1
CA0_140 A0_140 0 3.26e-16
LA0_140 A0_140 A0_141 6.4393e-10
BA0_141 A0_141 SDA_141 JJR area=1
CA0_141 A0_141 0 3.201e-16
LA0_141 A0_141 A0_142 6.4362e-10
BA0_142 A0_142 SDA_142 JJR area=1
CA0_142 A0_142 0 3.147e-16
LA0_142 A0_142 A0_143 6.4334e-10
BA0_143 A0_143 SDA_143 JJR area=1
CA0_143 A0_143 0 3.099e-16
LA0_143 A0_143 A0_144 6.4308e-10
BA0_144 A0_144 SDA_144 JJR area=1
CA0_144 A0_144 0 3.055e-16
LA0_144 A0_144 A0_145 6.4286e-10
BA0_145 A0_145 SDA_145 JJR area=1
CA0_145 A0_145 0 3.017e-16
LA0_145 A0_145 A0_146 6.4267e-10
BA0_146 A0_146 SDA_146 JJR area=1
CA0_146 A0_146 0 2.986e-16
LA0_146 A0_146 A0_147 6.4251e-10
BA0_147 A0_147 SDA_147 JJR area=1
CA0_147 A0_147 0 2.96e-16
LA0_147 A0_147 A0_148 6.4239e-10
BA0_148 A0_148 SDA_148 JJR area=1
CA0_148 A0_148 0 2.941e-16
LA0_148 A0_148 A0_149 6.423e-10
BA0_149 A0_149 SDA_149 JJR area=1
CA0_149 A0_149 0 2.928e-16
LA0_149 A0_149 A0_150 6.4224e-10
BA0_150 A0_150 SDA_150 JJR area=1
CA0_150 A0_150 0 2.921e-16
LA0_150 A0_150 A0_151 6.4222e-10
BA0_151 A0_151 SDA_151 JJR area=1
CA0_151 A0_151 0 2.92e-16
LA0_151 A0_151 A0_152 6.4222e-10
BA0_152 A0_152 SDA_152 JJR area=1
CA0_152 A0_152 0 2.92e-16
LA0_152 A0_152 A0_153 6.4222e-10
BA0_153 A0_153 SDA_153 JJR area=1
CA0_153 A0_153 0 2.92e-16
LA0_153 A0_153 A0_154 6.4222e-10
BA0_154 A0_154 SDA_154 JJR area=1
CA0_154 A0_154 0 2.92e-16
LA0_154 A0_154 A0_155 6.4222e-10
BA0_155 A0_155 SDA_155 JJR area=1
CA0_155 A0_155 0 2.92e-16
LA0_155 A0_155 A0_156 6.4222e-10
BA0_156 A0_156 SDA_156 JJR area=1
CA0_156 A0_156 0 2.92e-16
LA0_156 A0_156 A0_157 6.4222e-10
BA0_157 A0_157 SDA_157 JJR area=1
CA0_157 A0_157 0 2.92e-16
LA0_157 A0_157 A0_158 6.4222e-10
BA0_158 A0_158 SDA_158 JJR area=1
CA0_158 A0_158 0 2.92e-16
LA0_158 A0_158 A0_159 6.4222e-10
BA0_159 A0_159 SDA_159 JJR area=1
CA0_159 A0_159 0 2.92e-16
LA0_159 A0_159 A0_160 6.4222e-10
BA0_160 A0_160 SDA_160 JJR area=1
CA0_160 A0_160 0 2.92e-16
LA0_160 A0_160 A0_161 6.4222e-10
BA0_161 A0_161 SDA_161 JJR area=1
CA0_161 A0_161 0 2.92e-16
LA0_161 A0_161 A0_162 6.4222e-10
BA0_162 A0_162 SDA_162 JJR area=1
CA0_162 A0_162 0 2.92e-16
LA0_162 A0_162 A0_163 6.4222e-10
BA0_163 A0_163 SDA_163 JJR area=1
CA0_163 A0_163 0 2.92e-16
LA0_163 A0_163 A0_164 6.4222e-10
BA0_164 A0_164 SDA_164 JJR area=1
CA0_164 A0_164 0 2.92e-16
LA0_164 A0_164 A0_165 6.4222e-10
BA0_165 A0_165 SDA_165 JJR area=1
CA0_165 A0_165 0 2.92e-16
LA0_165 A0_165 A0_166 6.4222e-10
BA0_166 A0_166 SDA_166 JJR area=1
CA0_166 A0_166 0 2.92e-16
LA0_166 A0_166 A0_167 6.4222e-10
BA0_167 A0_167 SDA_167 JJR area=1
CA0_167 A0_167 0 2.92e-16
LA0_167 A0_167 A0_168 6.4222e-10
BA0_168 A0_168 SDA_168 JJR area=1
CA0_168 A0_168 0 2.92e-16
LA0_168 A0_168 A0_169 6.4222e-10
BA0_169 A0_169 SDA_169 JJR area=1
CA0_169 A0_169 0 2.92e-16
LA0_169 A0_169 A0_170 6.4222e-10
BA0_170 A0_170 SDA_170 JJR area=1
CA0_170 A0_170 0 2.92e-16
LA0_170 A0_170 A0_171 6.4222e-10
BA0_171 A0_171 SDA_171 JJR area=1
CA0_171 A0_171 0 2.92e-16
LA0_171 A0_171 A0_172 6.4222e-10
BA0_172 A0_172 SDA_172 JJR area=1
CA0_172 A0_172 0 2.92e-16
LA0_172 A0_172 A0_173 6.4222e-10
BA0_173 A0_173 SDA_173 JJR area=1
CA0_173 A0_173 0 2.92e-16
LA0_173 A0_173 A0_174 6.4222e-10
BA0_174 A0_174 SDA_174 JJR area=1
CA0_174 A0_174 0 2.92e-16
LA0_174 A0_174 A0_175 6.4222e-10
BA0_175 A0_175 SDA_175 JJR area=1
CA0_175 A0_175 0 2.92e-16
LA0_175 A0_175 A0_176 6.4222e-10
BA0_176 A0_176 SDA_176 JJR area=1
CA0_176 A0_176 0 2.92e-16
LA0_176 A0_176 A0_177 6.4222e-10
BA0_177 A0_177 SDA_177 JJR area=1
CA0_177 A0_177 0 2.92e-16
LA0_177 A0_177 A0_178 6.4222e-10
BA0_178 A0_178 SDA_178 JJR area=1
CA0_178 A0_178 0 2.92e-16
LA0_178 A0_178 A0_179 6.4222e-10
BA0_179 A0_179 SDA_179 JJR area=1
CA0_179 A0_179 0 2.92e-16
LA0_179 A0_179 A0_180 6.4222e-10
BA0_180 A0_180 SDA_180 JJR area=1
CA0_180 A0_180 0 2.92e-16
LA0_180 A0_180 A0_181 6.4222e-10
BA0_181 A0_181 SDA_181 JJR area=1
CA0_181 A0_181 0 2.92e-16
LA0_181 A0_181 A0_182 6.4222e-10
BA0_182 A0_182 SDA_182 JJR area=1
CA0_182 A0_182 0 2.92e-16
LA0_182 A0_182 A0_183 6.4222e-10
BA0_183 A0_183 SDA_183 JJR area=1
CA0_183 A0_183 0 2.92e-16
LA0_183 A0_183 A0_184 6.4222e-10
BA0_184 A0_184 SDA_184 JJR area=1
CA0_184 A0_184 0 2.92e-16
LA0_184 A0_184 A0_185 6.4222e-10
BA0_185 A0_185 SDA_185 JJR area=1
CA0_185 A0_185 0 2.92e-16
LA0_185 A0_185 A0_186 6.4222e-10
BA0_186 A0_186 SDA_186 JJR area=1
CA0_186 A0_186 0 2.92e-16
LA0_186 A0_186 A0_187 6.4222e-10
BA0_187 A0_187 SDA_187 JJR area=1
CA0_187 A0_187 0 2.92e-16
LA0_187 A0_187 A0_188 6.4222e-10
BA0_188 A0_188 SDA_188 JJR area=1
CA0_188 A0_188 0 2.92e-16
LA0_188 A0_188 A0_189 6.4222e-10
BA0_189 A0_189 SDA_189 JJR area=1
CA0_189 A0_189 0 2.92e-16
LA0_189 A0_189 A0_190 6.4222e-10
BA0_190 A0_190 SDA_190 JJR area=1
CA0_190 A0_190 0 2.92e-16
LA0_190 A0_190 A0_191 6.4222e-10
BA0_191 A0_191 SDA_191 JJR area=1
CA0_191 A0_191 0 2.92e-16
LA0_191 A0_191 A0_192 6.4222e-10
BA0_192 A0_192 SDA_192 JJR area=1
CA0_192 A0_192 0 2.92e-16
LA0_192 A0_192 A0_193 6.4222e-10
BA0_193 A0_193 SDA_193 JJR area=1
CA0_193 A0_193 0 2.92e-16
LA0_193 A0_193 A0_194 6.4222e-10
BA0_194 A0_194 SDA_194 JJR area=1
CA0_194 A0_194 0 2.92e-16
LA0_194 A0_194 A0_195 6.4222e-10
BA0_195 A0_195 SDA_195 JJR area=1
CA0_195 A0_195 0 2.92e-16
LA0_195 A0_195 A0_196 6.4222e-10
BA0_196 A0_196 SDA_196 JJR area=1
CA0_196 A0_196 0 2.92e-16
LA0_196 A0_196 A0_197 6.4222e-10
BA0_197 A0_197 SDA_197 JJR area=1
CA0_197 A0_197 0 2.92e-16
LA0_197 A0_197 A0_198 6.4222e-10
BA0_198 A0_198 SDA_198 JJR area=1
CA0_198 A0_198 0 2.92e-16
LA0_198 A0_198 A0_199 6.4222e-10
BA0_199 A0_199 SDA_199 JJR area=1
CA0_199 A0_199 0 2.92e-16
LA0_199 A0_199 A0_200 6.4222e-10
BA0_200 A0_200 SDA_200 JJR area=1
CA0_200 A0_200 0 2.92e-16
LA0_200 A0_200 A0_201 6.4222e-10
BA0_201 A0_201 SDA_201 JJR area=1
CA0_201 A0_201 0 2.92e-16
LA0_201 A0_201 A0_202 6.4222e-10
BA0_202 A0_202 SDA_202 JJR area=1
CA0_202 A0_202 0 2.92e-16
LA0_202 A0_202 A0_203 6.4222e-10
BA0_203 A0_203 SDA_203 JJR area=1
CA0_203 A0_203 0 2.92e-16
LA0_203 A0_203 A0_204 6.4222e-10
BA0_204 A0_204 SDA_204 JJR area=1
CA0_204 A0_204 0 2.92e-16
LA0_204 A0_204 A0_205 6.4222e-10
BA0_205 A0_205 SDA_205 JJR area=1
CA0_205 A0_205 0 2.92e-16
LA0_205 A0_205 A0_206 6.4222e-10
BA0_206 A0_206 SDA_206 JJR area=1
CA0_206 A0_206 0 2.92e-16
LA0_206 A0_206 A0_207 6.4222e-10
BA0_207 A0_207 SDA_207 JJR area=1
CA0_207 A0_207 0 2.92e-16
LA0_207 A0_207 A0_208 6.4222e-10
BA0_208 A0_208 SDA_208 JJR area=1
CA0_208 A0_208 0 2.92e-16
LA0_208 A0_208 A0_209 6.4222e-10
BA0_209 A0_209 SDA_209 JJR area=1
CA0_209 A0_209 0 2.92e-16
LA0_209 A0_209 A0_210 6.4222e-10
BA0_210 A0_210 SDA_210 JJR area=1
CA0_210 A0_210 0 2.92e-16
LA0_210 A0_210 A0_211 6.4222e-10
BA0_211 A0_211 SDA_211 JJR area=1
CA0_211 A0_211 0 2.92e-16
LA0_211 A0_211 A0_212 6.4222e-10
BA0_212 A0_212 SDA_212 JJR area=1
CA0_212 A0_212 0 2.92e-16
LA0_212 A0_212 A0_213 6.4222e-10
BA0_213 A0_213 SDA_213 JJR area=1
CA0_213 A0_213 0 2.92e-16
LA0_213 A0_213 A0_214 6.4222e-10
BA0_214 A0_214 SDA_214 JJR area=1
CA0_214 A0_214 0 2.92e-16
LA0_214 A0_214 A0_215 6.4222e-10
BA0_215 A0_215 SDA_215 JJR area=1
CA0_215 A0_215 0 2.92e-16
LA0_215 A0_215 A0_216 6.4222e-10
BA0_216 A0_216 SDA_216 JJR area=1
CA0_216 A0_216 0 2.92e-16
LA0_216 A0_216 A0_217 6.4222e-10
BA0_217 A0_217 SDA_217 JJR area=1
CA0_217 A0_217 0 2.92e-16
LA0_217 A0_217 A0_218 6.4222e-10
BA0_218 A0_218 SDA_218 JJR area=1
CA0_218 A0_218 0 2.92e-16
LA0_218 A0_218 A0_219 6.4222e-10
BA0_219 A0_219 SDA_219 JJR area=1
CA0_219 A0_219 0 2.92e-16
LA0_219 A0_219 A0_220 6.4222e-10
BA0_220 A0_220 SDA_220 JJR area=1
CA0_220 A0_220 0 2.92e-16
LA0_220 A0_220 A0_221 6.4222e-10
BA0_221 A0_221 SDA_221 JJR area=1
CA0_221 A0_221 0 2.92e-16
LA0_221 A0_221 A0_222 6.4222e-10
BA0_222 A0_222 SDA_222 JJR area=1
CA0_222 A0_222 0 2.92e-16
LA0_222 A0_222 A0_223 6.4222e-10
BA0_223 A0_223 SDA_223 JJR area=1
CA0_223 A0_223 0 2.92e-16
LA0_223 A0_223 A0_224 6.4222e-10
BA0_224 A0_224 SDA_224 JJR area=1
CA0_224 A0_224 0 2.92e-16
LA0_224 A0_224 A0_225 6.4222e-10
BA0_225 A0_225 SDA_225 JJR area=1
CA0_225 A0_225 0 2.92e-16
LA0_225 A0_225 A0_226 6.4222e-10
BA0_226 A0_226 SDA_226 JJR area=1
CA0_226 A0_226 0 2.92e-16
LA0_226 A0_226 A0_227 6.4222e-10
BA0_227 A0_227 SDA_227 JJR area=1
CA0_227 A0_227 0 2.92e-16
LA0_227 A0_227 A0_228 6.4222e-10
BA0_228 A0_228 SDA_228 JJR area=1
CA0_228 A0_228 0 2.92e-16
LA0_228 A0_228 A0_229 6.4222e-10
BA0_229 A0_229 SDA_229 JJR area=1
CA0_229 A0_229 0 2.92e-16
LA0_229 A0_229 A0_230 6.4222e-10
BA0_230 A0_230 SDA_230 JJR area=1
CA0_230 A0_230 0 2.92e-16
LA0_230 A0_230 A0_231 6.4222e-10
BA0_231 A0_231 SDA_231 JJR area=1
CA0_231 A0_231 0 2.92e-16
LA0_231 A0_231 A0_232 6.4222e-10
BA0_232 A0_232 SDA_232 JJR area=1
CA0_232 A0_232 0 2.92e-16
LA0_232 A0_232 A0_233 6.4222e-10
BA0_233 A0_233 SDA_233 JJR area=1
CA0_233 A0_233 0 2.92e-16
LA0_233 A0_233 A0_234 6.4222e-10
BA0_234 A0_234 SDA_234 JJR area=1
CA0_234 A0_234 0 2.92e-16
LA0_234 A0_234 A0_235 6.4222e-10
BA0_235 A0_235 SDA_235 JJR area=1
CA0_235 A0_235 0 2.92e-16
LA0_235 A0_235 A0_236 6.4222e-10
BA0_236 A0_236 SDA_236 JJR area=1
CA0_236 A0_236 0 2.92e-16
LA0_236 A0_236 A0_237 6.4222e-10
BA0_237 A0_237 SDA_237 JJR area=1
CA0_237 A0_237 0 2.92e-16
LA0_237 A0_237 A0_238 6.4222e-10
BA0_238 A0_238 SDA_238 JJR area=1
CA0_238 A0_238 0 2.92e-16
LA0_238 A0_238 A0_239 6.4222e-10
BA0_239 A0_239 SDA_239 JJR area=1
CA0_239 A0_239 0 2.92e-16
LA0_239 A0_239 A0_240 6.4222e-10
BA0_240 A0_240 SDA_240 JJR area=1
CA0_240 A0_240 0 2.92e-16
LA0_240 A0_240 A0_241 6.4222e-10
BA0_241 A0_241 SDA_241 JJR area=1
CA0_241 A0_241 0 2.92e-16
LA0_241 A0_241 A0_242 6.4222e-10
BA0_242 A0_242 SDA_242 JJR area=1
CA0_242 A0_242 0 2.92e-16
LA0_242 A0_242 A0_243 6.4222e-10
BA0_243 A0_243 SDA_243 JJR area=1
CA0_243 A0_243 0 2.92e-16
LA0_243 A0_243 A0_244 6.4222e-10
BA0_244 A0_244 SDA_244 JJR area=1
CA0_244 A0_244 0 2.92e-16
LA0_244 A0_244 A0_245 6.4222e-10
BA0_245 A0_245 SDA_245 JJR area=1
CA0_245 A0_245 0 2.92e-16
LA0_245 A0_245 A0_246 6.4222e-10
BA0_246 A0_246 SDA_246 JJR area=1
CA0_246 A0_246 0 2.92e-16
LA0_246 A0_246 A0_247 6.4222e-10
BA0_247 A0_247 SDA_247 JJR area=1
CA0_247 A0_247 0 2.92e-16
LA0_247 A0_247 A0_248 6.4222e-10
BA0_248 A0_248 SDA_248 JJR area=1
CA0_248 A0_248 0 2.92e-16
LA0_248 A0_248 A0_249 6.4222e-10
BA0_249 A0_249 SDA_249 JJR area=1
CA0_249 A0_249 0 2.92e-16
LA0_249 A0_249 A0_250 6.4222e-10
BA0_250 A0_250 SDA_250 JJR area=1
CA0_250 A0_250 0 2.92e-16
LA0_250 A0_250 A0_251 6.4222e-10
BA0_251 A0_251 SDA_251 JJR area=1
CA0_251 A0_251 0 2.921e-16
LA0_251 A0_251 A0_252 6.4224e-10
BA0_252 A0_252 SDA_252 JJR area=1
CA0_252 A0_252 0 2.928e-16
LA0_252 A0_252 A0_253 6.423e-10
BA0_253 A0_253 SDA_253 JJR area=1
CA0_253 A0_253 0 2.941e-16
LA0_253 A0_253 A0_254 6.4239e-10
BA0_254 A0_254 SDA_254 JJR area=1
CA0_254 A0_254 0 2.96e-16
LA0_254 A0_254 A0_255 6.4251e-10
BA0_255 A0_255 SDA_255 JJR area=1
CA0_255 A0_255 0 2.986e-16
LA0_255 A0_255 A0_256 6.4267e-10
BA0_256 A0_256 SDA_256 JJR area=1
CA0_256 A0_256 0 3.017e-16
LA0_256 A0_256 A0_257 6.4286e-10
BA0_257 A0_257 SDA_257 JJR area=1
CA0_257 A0_257 0 3.055e-16
LA0_257 A0_257 A0_258 6.4308e-10
BA0_258 A0_258 SDA_258 JJR area=1
CA0_258 A0_258 0 3.099e-16
LA0_258 A0_258 A0_259 6.4334e-10
BA0_259 A0_259 SDA_259 JJR area=1
CA0_259 A0_259 0 3.147e-16
LA0_259 A0_259 A0_260 6.4362e-10
BA0_260 A0_260 SDA_260 JJR area=1
CA0_260 A0_260 0 3.201e-16
LA0_260 A0_260 A0_261 6.4393e-10
BA0_261 A0_261 SDA_261 JJR area=1
CA0_261 A0_261 0 3.26e-16
LA0_261 A0_261 A0_262 6.4426e-10
BA0_262 A0_262 SDA_262 JJR area=1
CA0_262 A0_262 0 3.324e-16
LA0_262 A0_262 A0_263 6.4462e-10
BA0_263 A0_263 SDA_263 JJR area=1
CA0_263 A0_263 0 3.391e-16
LA0_263 A0_263 A0_264 6.45e-10
BA0_264 A0_264 SDA_264 JJR area=1
CA0_264 A0_264 0 3.462e-16
LA0_264 A0_264 A0_265 6.454e-10
BA0_265 A0_265 SDA_265 JJR area=1
CA0_265 A0_265 0 3.536e-16
LA0_265 A0_265 A0_266 6.4581e-10
BA0_266 A0_266 SDA_266 JJR area=1
CA0_266 A0_266 0 3.613e-16
LA0_266 A0_266 A0_267 6.4624e-10
BA0_267 A0_267 SDA_267 JJR area=1
CA0_267 A0_267 0 3.692e-16
LA0_267 A0_267 A0_268 6.4668e-10
BA0_268 A0_268 SDA_268 JJR area=1
CA0_268 A0_268 0 3.772e-16
LA0_268 A0_268 A0_269 6.4713e-10
BA0_269 A0_269 SDA_269 JJR area=1
CA0_269 A0_269 0 3.855e-16
LA0_269 A0_269 A0_270 6.4758e-10
BA0_270 A0_270 SDA_270 JJR area=1
CA0_270 A0_270 0 3.938e-16
LA0_270 A0_270 A0_271 6.4803e-10
BA0_271 A0_271 SDA_271 JJR area=1
CA0_271 A0_271 0 4.021e-16
LA0_271 A0_271 A0_272 6.4849e-10
BA0_272 A0_272 SDA_272 JJR area=1
CA0_272 A0_272 0 4.104e-16
LA0_272 A0_272 A0_273 6.4894e-10
BA0_273 A0_273 SDA_273 JJR area=1
CA0_273 A0_273 0 4.186e-16
LA0_273 A0_273 A0_274 6.4939e-10
BA0_274 A0_274 SDA_274 JJR area=1
CA0_274 A0_274 0 4.267e-16
LA0_274 A0_274 A0_275 6.4983e-10
BA0_275 A0_275 SDA_275 JJR area=1
CA0_275 A0_275 0 4.346e-16
LA0_275 A0_275 A0_276 6.5026e-10
BA0_276 A0_276 SDA_276 JJR area=1
CA0_276 A0_276 0 4.422e-16
LA0_276 A0_276 A0_277 6.5067e-10
BA0_277 A0_277 SDA_277 JJR area=1
CA0_277 A0_277 0 4.496e-16
LA0_277 A0_277 A0_278 6.5107e-10
BA0_278 A0_278 SDA_278 JJR area=1
CA0_278 A0_278 0 4.567e-16
LA0_278 A0_278 A0_279 6.5145e-10
BA0_279 A0_279 SDA_279 JJR area=1
CA0_279 A0_279 0 4.635e-16
LA0_279 A0_279 A0_280 6.5181e-10
BA0_280 A0_280 SDA_280 JJR area=1
CA0_280 A0_280 0 4.698e-16
LA0_280 A0_280 A0_281 6.5214e-10
BA0_281 A0_281 SDA_281 JJR area=1
CA0_281 A0_281 0 4.757e-16
LA0_281 A0_281 A0_282 6.5245e-10
BA0_282 A0_282 SDA_282 JJR area=1
CA0_282 A0_282 0 4.811e-16
LA0_282 A0_282 A0_283 6.5273e-10
BA0_283 A0_283 SDA_283 JJR area=1
CA0_283 A0_283 0 4.86e-16
LA0_283 A0_283 A0_284 6.5299e-10
BA0_284 A0_284 SDA_284 JJR area=1
CA0_284 A0_284 0 4.903e-16
LA0_284 A0_284 A0_285 6.5321e-10
BA0_285 A0_285 SDA_285 JJR area=1
CA0_285 A0_285 0 4.941e-16
LA0_285 A0_285 A0_286 6.534e-10
BA0_286 A0_286 SDA_286 JJR area=1
CA0_286 A0_286 0 4.973e-16
LA0_286 A0_286 A0_287 6.5356e-10
BA0_287 A0_287 SDA_287 JJR area=1
CA0_287 A0_287 0 4.998e-16
LA0_287 A0_287 A0_288 6.5368e-10
BA0_288 A0_288 SDA_288 JJR area=1
CA0_288 A0_288 0 5.018e-16
LA0_288 A0_288 A0_289 6.5377e-10
BA0_289 A0_289 SDA_289 JJR area=1
CA0_289 A0_289 0 5.031e-16
LA0_289 A0_289 A0_290 6.5382e-10
BA0_290 A0_290 SDA_290 JJR area=1
CA0_290 A0_290 0 5.037e-16
LA0_290 A0_290 A0_291 6.5384e-10
BA0_291 A0_291 0 JJR area=1
CA0_291 A0_291 0 5.038e-16
LA0_291 A0_291 A0_292 6.5385e-10
BA0_292 A0_292 0 JJR area=1
CA0_292 A0_292 0 5.038e-16
LA0_292 A0_292 A0_293 6.5385e-10
BA0_293 A0_293 0 JJR area=1
CA0_293 A0_293 0 5.038e-16
LA0_293 A0_293 A0_294 6.5385e-10
BA0_294 A0_294 0 JJR area=1
CA0_294 A0_294 0 5.038e-16
LA0_294 A0_294 A0_295 6.5385e-10
BA0_295 A0_295 0 JJR area=1
CA0_295 A0_295 0 5.038e-16
LA0_295 A0_295 A0_296 6.5385e-10
BA0_296 A0_296 0 JJR area=1
CA0_296 A0_296 0 5.038e-16
LA0_296 A0_296 A0_297 6.5385e-10
BA0_297 A0_297 0 JJR area=1
CA0_297 A0_297 0 5.038e-16
LA0_297 A0_297 A0_298 6.5385e-10
BA0_298 A0_298 0 JJR area=1
CA0_298 A0_298 0 5.038e-16
LA0_298 A0_298 A0_299 6.5385e-10
BA0_299 A0_299 0 JJR area=1
CA0_299 A0_299 0 5.038e-16
LA0_299 A0_299 A0_300 6.5385e-10
BA0_300 A0_300 0 JJR area=1
CA0_300 A0_300 0 5.038e-16
LA0_300 A0_300 A0_301 6.5385e-10
BA0_301 A0_301 0 JJR area=1
CA0_301 A0_301 0 5.038e-16
LA0_301 A0_301 A0_302 6.5385e-10
BA0_302 A0_302 0 JJR area=1
CA0_302 A0_302 0 5.038e-16
LA0_302 A0_302 A0_303 6.5385e-10
BA0_303 A0_303 0 JJR area=1
CA0_303 A0_303 0 5.038e-16
LA0_303 A0_303 A0_304 6.5385e-10
BA0_304 A0_304 0 JJR area=1
CA0_304 A0_304 0 5.038e-16
LA0_304 A0_304 A0_305 6.5385e-10
BA0_305 A0_305 0 JJR area=1
CA0_305 A0_305 0 5.038e-16
LA0_305 A0_305 A0_306 6.5385e-10
BA0_306 A0_306 0 JJR area=1
CA0_306 A0_306 0 5.038e-16
LA0_306 A0_306 A0_307 6.5385e-10
BA0_307 A0_307 0 JJR area=1
CA0_307 A0_307 0 5.038e-16
LA0_307 A0_307 A0_308 6.5385e-10
BA0_308 A0_308 0 JJR area=1
CA0_308 A0_308 0 5.038e-16
LA0_308 A0_308 A0_309 6.5385e-10
BA0_309 A0_309 0 JJR area=1
CA0_309 A0_309 0 5.038e-16
LA0_309 A0_309 A0_310 6.5385e-10
BA0_310 A0_310 0 JJR area=1
CA0_310 A0_310 0 5.038e-16
LA0_310 A0_310 A0_311 6.5385e-10
BA0_311 A0_311 MA_311 JJR area=1
CA0_311 A0_311 0 5.038e-16
LA0_311 A0_311 A0_312 6.5385e-10
BA0_312 A0_312 MA_312 JJR area=1
CA0_312 A0_312 0 5.038e-16
LA0_312 A0_312 A0_313 6.5385e-10
BA0_313 A0_313 MA_313 JJR area=1
CA0_313 A0_313 0 5.038e-16
LA0_313 A0_313 A0_314 6.5385e-10
BA0_314 A0_314 MA_314 JJR area=1
CA0_314 A0_314 0 5.038e-16
LA0_314 A0_314 A0_315 6.5385e-10
BA0_315 A0_315 MA_315 JJR area=1
CA0_315 A0_315 0 5.038e-16
LA0_315 A0_315 A0_316 6.5385e-10
BA0_316 A0_316 MA_316 JJR area=1
CA0_316 A0_316 0 5.038e-16
LA0_316 A0_316 A0_317 6.5385e-10
BA0_317 A0_317 MA_317 JJR area=1
CA0_317 A0_317 0 5.038e-16
LA0_317 A0_317 A0_318 6.5385e-10
BA0_318 A0_318 MA_318 JJR area=1
CA0_318 A0_318 0 5.038e-16
LA0_318 A0_318 A0_319 6.5385e-10
BA0_319 A0_319 MA_319 JJR area=1
CA0_319 A0_319 0 5.038e-16
LA0_319 A0_319 A0_320 6.5385e-10
BA0_320 A0_320 MA_320 JJR area=1
CA0_320 A0_320 0 5.038e-16
LA0_320 A0_320 A0_321 6.5385e-10
BA0_321 A0_321 MA_321 JJR area=1
CA0_321 A0_321 0 5.038e-16
LA0_321 A0_321 A0_322 6.5385e-10
BA0_322 A0_322 MA_322 JJR area=1
CA0_322 A0_322 0 5.038e-16
LA0_322 A0_322 A0_323 6.5385e-10
BA0_323 A0_323 MA_323 JJR area=1
CA0_323 A0_323 0 5.038e-16
LA0_323 A0_323 A0_324 6.5385e-10
BA0_324 A0_324 MA_324 JJR area=1
CA0_324 A0_324 0 5.038e-16
LA0_324 A0_324 A0_325 6.5385e-10
BA0_325 A0_325 MA_325 JJR area=1
CA0_325 A0_325 0 5.038e-16
LA0_325 A0_325 A0_326 6.5385e-10
BA0_326 A0_326 MA_326 JJR area=1
CA0_326 A0_326 0 5.038e-16
LA0_326 A0_326 A0_327 6.5385e-10
BA0_327 A0_327 MA_327 JJR area=1
CA0_327 A0_327 0 5.038e-16
LA0_327 A0_327 A0_328 6.5385e-10
BA0_328 A0_328 MA_328 JJR area=1
CA0_328 A0_328 0 5.038e-16
LA0_328 A0_328 A0_329 6.5385e-10
BA0_329 A0_329 MA_329 JJR area=1
CA0_329 A0_329 0 5.038e-16
LA0_329 A0_329 A0_330 6.5385e-10
BA0_330 A0_330 MA_330 JJR area=1
CA0_330 A0_330 0 5.038e-16
LA0_330 A0_330 A0_331 6.5385e-10
BA0_331 A0_331 MA_331 JJR area=1
CA0_331 A0_331 0 5.038e-16
LA0_331 A0_331 A0_332 6.5385e-10
BA0_332 A0_332 MA_332 JJR area=1
CA0_332 A0_332 0 5.038e-16
LA0_332 A0_332 A0_333 6.5385e-10
BA0_333 A0_333 MA_333 JJR area=1
CA0_333 A0_333 0 5.038e-16
LA0_333 A0_333 A0_334 6.5385e-10
BA0_334 A0_334 MA_334 JJR area=1
CA0_334 A0_334 0 5.038e-16
LA0_334 A0_334 A0_335 6.5385e-10
BA0_335 A0_335 MA_335 JJR area=1
CA0_335 A0_335 0 5.038e-16
LA0_335 A0_335 A0_336 6.5385e-10
BA0_336 A0_336 MA_336 JJR area=1
CA0_336 A0_336 0 5.038e-16
LA0_336 A0_336 A0_337 6.5385e-10
BA0_337 A0_337 MA_337 JJR area=1
CA0_337 A0_337 0 5.038e-16
LA0_337 A0_337 A0_338 6.5385e-10
BA0_338 A0_338 MA_338 JJR area=1
CA0_338 A0_338 0 5.038e-16
LA0_338 A0_338 A0_339 6.5385e-10
BA0_339 A0_339 MA_339 JJR area=1
CA0_339 A0_339 0 5.038e-16
LA0_339 A0_339 A0_340 6.5385e-10
BA0_340 A0_340 MA_340 JJR area=1
CA0_340 A0_340 0 5.038e-16
LA0_340 A0_340 A0_341 6.5385e-10
BA0_341 A0_341 MA_341 JJR area=1
CA0_341 A0_341 0 5.038e-16
LA0_341 A0_341 A0_342 6.5385e-10
BA0_342 A0_342 MA_342 JJR area=1
CA0_342 A0_342 0 5.038e-16
LA0_342 A0_342 A0_343 6.5385e-10
BA0_343 A0_343 MA_343 JJR area=1
CA0_343 A0_343 0 5.038e-16
LA0_343 A0_343 A0_344 6.5385e-10
BA0_344 A0_344 MA_344 JJR area=1
CA0_344 A0_344 0 5.038e-16
LA0_344 A0_344 A0_345 6.5385e-10
BA0_345 A0_345 MA_345 JJR area=1
CA0_345 A0_345 0 5.038e-16
LA0_345 A0_345 A0_346 6.5385e-10
BA0_346 A0_346 MA_346 JJR area=1
CA0_346 A0_346 0 5.038e-16
LA0_346 A0_346 A0_347 6.5385e-10
BA0_347 A0_347 MA_347 JJR area=1
CA0_347 A0_347 0 5.038e-16
LA0_347 A0_347 A0_348 6.5385e-10
BA0_348 A0_348 MA_348 JJR area=1
CA0_348 A0_348 0 5.038e-16
LA0_348 A0_348 A0_349 6.5385e-10
BA0_349 A0_349 MA_349 JJR area=1
CA0_349 A0_349 0 5.038e-16
LA0_349 A0_349 A0_350 6.5385e-10
BA0_350 A0_350 MA_350 JJR area=1
CA0_350 A0_350 0 5.038e-16
LA0_350 A0_350 A0_351 6.5385e-10
BA0_351 A0_351 MA_351 JJR area=1
CA0_351 A0_351 0 5.038e-16
LA0_351 A0_351 A0_352 6.5385e-10
BA0_352 A0_352 0 JJR area=1
CA0_352 A0_352 0 5.038e-16
LA0_352 A0_352 A0_353 6.5385e-10
BA0_353 A0_353 0 JJR area=1
CA0_353 A0_353 0 5.038e-16
LA0_353 A0_353 A0_354 6.5385e-10
BA0_354 A0_354 0 JJR area=1
CA0_354 A0_354 0 5.038e-16
LA0_354 A0_354 A0_355 6.5385e-10
BA0_355 A0_355 0 JJR area=1
CA0_355 A0_355 0 5.038e-16
LA0_355 A0_355 A0_356 6.5385e-10
BA0_356 A0_356 0 JJR area=1
CA0_356 A0_356 0 5.038e-16
LA0_356 A0_356 A0_357 6.5385e-10
BA0_357 A0_357 0 JJR area=1
CA0_357 A0_357 0 5.038e-16
LA0_357 A0_357 A0_358 6.5385e-10
BA0_358 A0_358 0 JJR area=1
CA0_358 A0_358 0 5.038e-16
LA0_358 A0_358 A0_359 6.5385e-10
BA0_359 A0_359 0 JJR area=1
CA0_359 A0_359 0 5.038e-16
LA0_359 A0_359 A0_360 6.5385e-10
BA0_360 A0_360 0 JJR area=1
CA0_360 A0_360 0 5.038e-16
LA0_360 A0_360 A0_361 6.5385e-10
BA0_361 A0_361 0 JJR area=1
CA0_361 A0_361 0 5.038e-16
BINJ_A0 A0_0 0 JJI area=1
IINJ_A0 0 A0_0 pwl(0 0 20p 0 30p 1.933e-07 50p 0)
LCATCH_A0 A0_361 0 20n
IACC_A0_10 0 A0_10 pwl(0 0 50p 0 60p 4.027e-09 200p 4.027e-09 210p 0)
IACC_A0_11 0 A0_11 pwl(0 0 50p 0 60p 4.027e-09 200p 4.027e-09 210p 0)
IACC_A0_12 0 A0_12 pwl(0 0 50p 0 60p 4.027e-09 200p 4.027e-09 210p 0)
IACC_A0_13 0 A0_13 pwl(0 0 50p 0 60p 4.027e-09 200p 4.027e-09 210p 0)
IACC_A0_14 0 A0_14 pwl(0 0 50p 0 60p 4.027e-09 200p 4.027e-09 210p 0)
IACC_A0_15 0 A0_15 pwl(0 0 50p 0 60p 4.027e-09 200p 4.027e-09 210p 0)
IACC_A0_16 0 A0_16 pwl(0 0 50p 0 60p 4.027e-09 200p 4.027e-09 210p 0)
IACC_A0_17 0 A0_17 pwl(0 0 50p 0 60p 4.027e-09 200p 4.027e-09 210p 0)
IACC_A0_18 0 A0_18 pwl(0 0 50p 0 60p 4.027e-09 200p 4.027e-09 210p 0)
IACC_A0_19 0 A0_19 pwl(0 0 50p 0 60p 4.027e-09 200p 4.027e-09 210p 0)
IACC_A0_20 0 A0_20 pwl(0 0 50p 0 60p 4.027e-09 200p 4.027e-09 210p 0)
IACC_A0_21 0 A0_21 pwl(0 0 50p 0 60p 4.027e-09 200p 4.027e-09 210p 0)
IACC_A0_22 0 A0_22 pwl(0 0 50p 0 60p 4.027e-09 200p 4.027e-09 210p 0)
IACC_A0_23 0 A0_23 pwl(0 0 50p 0 60p 4.027e-09 200p 4.027e-09 210p 0)
IACC_A0_24 0 A0_24 pwl(0 0 50p 0 60p 4.027e-09 200p 4.027e-09 210p 0)
IACC_A0_25 0 A0_25 pwl(0 0 50p 0 60p 4.027e-09 200p 4.027e-09 210p 0)
IACC_A0_26 0 A0_26 pwl(0 0 50p 0 60p 4.027e-09 200p 4.027e-09 210p 0)
IACC_A0_27 0 A0_27 pwl(0 0 50p 0 60p 4.027e-09 200p 4.027e-09 210p 0)
IACC_A0_28 0 A0_28 pwl(0 0 50p 0 60p 4.027e-09 200p 4.027e-09 210p 0)
IACC_A0_29 0 A0_29 pwl(0 0 50p 0 60p 4.027e-09 200p 4.027e-09 210p 0)
IACC_A0_30 0 A0_30 pwl(0 0 50p 0 60p 4.027e-09 200p 4.027e-09 210p 0)
IACC_A0_31 0 A0_31 pwl(0 0 50p 0 60p 4.027e-09 200p 4.027e-09 210p 0)
IACC_A0_32 0 A0_32 pwl(0 0 50p 0 60p 4.027e-09 200p 4.027e-09 210p 0)
IACC_A0_33 0 A0_33 pwl(0 0 50p 0 60p 4.027e-09 200p 4.027e-09 210p 0)
IACC_A0_34 0 A0_34 pwl(0 0 50p 0 60p 4.027e-09 200p 4.027e-09 210p 0)
IACC_A0_35 0 A0_35 pwl(0 0 50p 0 60p 4.027e-09 200p 4.027e-09 210p 0)
IACC_A0_36 0 A0_36 pwl(0 0 50p 0 60p 4.027e-09 200p 4.027e-09 210p 0)
IACC_A0_37 0 A0_37 pwl(0 0 50p 0 60p 4.027e-09 200p 4.027e-09 210p 0)
IACC_A0_38 0 A0_38 pwl(0 0 50p 0 60p 4.027e-09 200p 4.027e-09 210p 0)
IACC_A0_39 0 A0_39 pwl(0 0 50p 0 60p 4.027e-09 200p 4.027e-09 210p 0)
IACC_A0_40 0 A0_40 pwl(0 0 50p 0 60p 4.027e-09 200p 4.027e-09 210p 0)
IACC_A0_41 0 A0_41 pwl(0 0 50p 0 60p 4.027e-09 200p 4.027e-09 210p 0)
IACC_A0_42 0 A0_42 pwl(0 0 50p 0 60p 4.027e-09 200p 4.027e-09 210p 0)
IACC_A0_43 0 A0_43 pwl(0 0 50p 0 60p 4.027e-09 200p 4.027e-09 210p 0)
IACC_A0_44 0 A0_44 pwl(0 0 50p 0 60p 4.027e-09 200p 4.027e-09 210p 0)
IACC_A0_45 0 A0_45 pwl(0 0 50p 0 60p 4.027e-09 200p 4.027e-09 210p 0)
IACC_A0_46 0 A0_46 pwl(0 0 50p 0 60p 4.027e-09 200p 4.027e-09 210p 0)
IACC_A0_47 0 A0_47 pwl(0 0 50p 0 60p 4.027e-09 200p 4.027e-09 210p 0)
IACC_A0_48 0 A0_48 pwl(0 0 50p 0 60p 4.027e-09 200p 4.027e-09 210p 0)
IACC_A0_49 0 A0_49 pwl(0 0 50p 0 60p 4.027e-09 200p 4.027e-09 210p 0)
BA1_0 A1_0 0 JJR area=1
CA1_0 A1_0 0 5.038e-16
LA1_0 A1_0 A1_1 6.5385e-10
BA1_1 A1_1 0 JJR area=1
CA1_1 A1_1 0 5.038e-16
LA1_1 A1_1 A1_2 6.5385e-10
BA1_2 A1_2 0 JJR area=1
CA1_2 A1_2 0 5.038e-16
LA1_2 A1_2 A1_3 6.5385e-10
BA1_3 A1_3 0 JJR area=1
CA1_3 A1_3 0 5.038e-16
LA1_3 A1_3 A1_4 6.5385e-10
BA1_4 A1_4 0 JJR area=1
CA1_4 A1_4 0 5.038e-16
LA1_4 A1_4 A1_5 6.5385e-10
BA1_5 A1_5 0 JJR area=1
CA1_5 A1_5 0 5.038e-16
LA1_5 A1_5 A1_6 6.5385e-10
BA1_6 A1_6 0 JJR area=1
CA1_6 A1_6 0 5.038e-16
LA1_6 A1_6 A1_7 6.5385e-10
BA1_7 A1_7 0 JJR area=1
CA1_7 A1_7 0 5.038e-16
LA1_7 A1_7 A1_8 6.5385e-10
BA1_8 A1_8 0 JJR area=1
CA1_8 A1_8 0 5.038e-16
LA1_8 A1_8 A1_9 6.5385e-10
BA1_9 A1_9 0 JJR area=1
CA1_9 A1_9 0 5.038e-16
LA1_9 A1_9 A1_10 6.5385e-10
BA1_10 A1_10 0 JJR area=1
CA1_10 A1_10 0 5.038e-16
LA1_10 A1_10 A1_11 6.5385e-10
BA1_11 A1_11 0 JJR area=1
CA1_11 A1_11 0 5.038e-16
LA1_11 A1_11 A1_12 6.5385e-10
BA1_12 A1_12 0 JJR area=1
CA1_12 A1_12 0 5.038e-16
LA1_12 A1_12 A1_13 6.5385e-10
BA1_13 A1_13 0 JJR area=1
CA1_13 A1_13 0 5.038e-16
LA1_13 A1_13 A1_14 6.5385e-10
BA1_14 A1_14 0 JJR area=1
CA1_14 A1_14 0 5.038e-16
LA1_14 A1_14 A1_15 6.5385e-10
BA1_15 A1_15 0 JJR area=1
CA1_15 A1_15 0 5.038e-16
LA1_15 A1_15 A1_16 6.5385e-10
BA1_16 A1_16 0 JJR area=1
CA1_16 A1_16 0 5.038e-16
LA1_16 A1_16 A1_17 6.5385e-10
BA1_17 A1_17 0 JJR area=1
CA1_17 A1_17 0 5.038e-16
LA1_17 A1_17 A1_18 6.5385e-10
BA1_18 A1_18 0 JJR area=1
CA1_18 A1_18 0 5.038e-16
LA1_18 A1_18 A1_19 6.5385e-10
BA1_19 A1_19 0 JJR area=1
CA1_19 A1_19 0 5.038e-16
LA1_19 A1_19 A1_20 6.5385e-10
BA1_20 A1_20 0 JJR area=1
CA1_20 A1_20 0 5.038e-16
LA1_20 A1_20 A1_21 6.5385e-10
BA1_21 A1_21 0 JJR area=1
CA1_21 A1_21 0 5.038e-16
LA1_21 A1_21 A1_22 6.5385e-10
BA1_22 A1_22 0 JJR area=1
CA1_22 A1_22 0 5.038e-16
LA1_22 A1_22 A1_23 6.5385e-10
BA1_23 A1_23 0 JJR area=1
CA1_23 A1_23 0 5.038e-16
LA1_23 A1_23 A1_24 6.5385e-10
BA1_24 A1_24 0 JJR area=1
CA1_24 A1_24 0 5.038e-16
LA1_24 A1_24 A1_25 6.5385e-10
BA1_25 A1_25 0 JJR area=1
CA1_25 A1_25 0 5.038e-16
LA1_25 A1_25 A1_26 6.5385e-10
BA1_26 A1_26 0 JJR area=1
CA1_26 A1_26 0 5.038e-16
LA1_26 A1_26 A1_27 6.5385e-10
BA1_27 A1_27 0 JJR area=1
CA1_27 A1_27 0 5.038e-16
LA1_27 A1_27 A1_28 6.5385e-10
BA1_28 A1_28 0 JJR area=1
CA1_28 A1_28 0 5.038e-16
LA1_28 A1_28 A1_29 6.5385e-10
BA1_29 A1_29 0 JJR area=1
CA1_29 A1_29 0 5.038e-16
LA1_29 A1_29 A1_30 6.5385e-10
BA1_30 A1_30 0 JJR area=1
CA1_30 A1_30 0 5.038e-16
LA1_30 A1_30 A1_31 6.5385e-10
BA1_31 A1_31 0 JJR area=1
CA1_31 A1_31 0 5.038e-16
LA1_31 A1_31 A1_32 6.5385e-10
BA1_32 A1_32 0 JJR area=1
CA1_32 A1_32 0 5.038e-16
LA1_32 A1_32 A1_33 6.5385e-10
BA1_33 A1_33 0 JJR area=1
CA1_33 A1_33 0 5.038e-16
LA1_33 A1_33 A1_34 6.5385e-10
BA1_34 A1_34 0 JJR area=1
CA1_34 A1_34 0 5.038e-16
LA1_34 A1_34 A1_35 6.5385e-10
BA1_35 A1_35 0 JJR area=1
CA1_35 A1_35 0 5.038e-16
LA1_35 A1_35 A1_36 6.5385e-10
BA1_36 A1_36 0 JJR area=1
CA1_36 A1_36 0 5.038e-16
LA1_36 A1_36 A1_37 6.5385e-10
BA1_37 A1_37 0 JJR area=1
CA1_37 A1_37 0 5.038e-16
LA1_37 A1_37 A1_38 6.5385e-10
BA1_38 A1_38 0 JJR area=1
CA1_38 A1_38 0 5.038e-16
LA1_38 A1_38 A1_39 6.5385e-10
BA1_39 A1_39 0 JJR area=1
CA1_39 A1_39 0 5.038e-16
LA1_39 A1_39 A1_40 6.5385e-10
BA1_40 A1_40 0 JJR area=1
CA1_40 A1_40 0 5.038e-16
LA1_40 A1_40 A1_41 6.5385e-10
BA1_41 A1_41 0 JJR area=1
CA1_41 A1_41 0 5.038e-16
LA1_41 A1_41 A1_42 6.5385e-10
BA1_42 A1_42 0 JJR area=1
CA1_42 A1_42 0 5.038e-16
LA1_42 A1_42 A1_43 6.5385e-10
BA1_43 A1_43 0 JJR area=1
CA1_43 A1_43 0 5.038e-16
LA1_43 A1_43 A1_44 6.5385e-10
BA1_44 A1_44 0 JJR area=1
CA1_44 A1_44 0 5.038e-16
LA1_44 A1_44 A1_45 6.5385e-10
BA1_45 A1_45 0 JJR area=1
CA1_45 A1_45 0 5.038e-16
LA1_45 A1_45 A1_46 6.5385e-10
BA1_46 A1_46 0 JJR area=1
CA1_46 A1_46 0 5.038e-16
LA1_46 A1_46 A1_47 6.5385e-10
BA1_47 A1_47 0 JJR area=1
CA1_47 A1_47 0 5.038e-16
LA1_47 A1_47 A1_48 6.5385e-10
BA1_48 A1_48 0 JJR area=1
CA1_48 A1_48 0 5.038e-16
LA1_48 A1_48 A1_49 6.5385e-10
BA1_49 A1_49 0 JJR area=1
CA1_49 A1_49 0 5.038e-16
LA1_49 A1_49 A1_50 6.5385e-10
BA1_50 A1_50 MA_50 JJR area=1
CA1_50 A1_50 0 5.038e-16
LA1_50 A1_50 A1_51 6.5385e-10
BA1_51 A1_51 MA_51 JJR area=1
CA1_51 A1_51 0 5.038e-16
LA1_51 A1_51 A1_52 6.5385e-10
BA1_52 A1_52 MA_52 JJR area=1
CA1_52 A1_52 0 5.038e-16
LA1_52 A1_52 A1_53 6.5385e-10
BA1_53 A1_53 MA_53 JJR area=1
CA1_53 A1_53 0 5.038e-16
LA1_53 A1_53 A1_54 6.5385e-10
BA1_54 A1_54 MA_54 JJR area=1
CA1_54 A1_54 0 5.038e-16
LA1_54 A1_54 A1_55 6.5385e-10
BA1_55 A1_55 MA_55 JJR area=1
CA1_55 A1_55 0 5.038e-16
LA1_55 A1_55 A1_56 6.5385e-10
BA1_56 A1_56 MA_56 JJR area=1
CA1_56 A1_56 0 5.038e-16
LA1_56 A1_56 A1_57 6.5385e-10
BA1_57 A1_57 MA_57 JJR area=1
CA1_57 A1_57 0 5.038e-16
LA1_57 A1_57 A1_58 6.5385e-10
BA1_58 A1_58 MA_58 JJR area=1
CA1_58 A1_58 0 5.038e-16
LA1_58 A1_58 A1_59 6.5385e-10
BA1_59 A1_59 MA_59 JJR area=1
CA1_59 A1_59 0 5.038e-16
LA1_59 A1_59 A1_60 6.5385e-10
BA1_60 A1_60 MA_60 JJR area=1
CA1_60 A1_60 0 5.038e-16
LA1_60 A1_60 A1_61 6.5385e-10
BA1_61 A1_61 MA_61 JJR area=1
CA1_61 A1_61 0 5.038e-16
LA1_61 A1_61 A1_62 6.5385e-10
BA1_62 A1_62 MA_62 JJR area=1
CA1_62 A1_62 0 5.038e-16
LA1_62 A1_62 A1_63 6.5385e-10
BA1_63 A1_63 MA_63 JJR area=1
CA1_63 A1_63 0 5.038e-16
LA1_63 A1_63 A1_64 6.5385e-10
BA1_64 A1_64 MA_64 JJR area=1
CA1_64 A1_64 0 5.038e-16
LA1_64 A1_64 A1_65 6.5385e-10
BA1_65 A1_65 MA_65 JJR area=1
CA1_65 A1_65 0 5.038e-16
LA1_65 A1_65 A1_66 6.5385e-10
BA1_66 A1_66 MA_66 JJR area=1
CA1_66 A1_66 0 5.038e-16
LA1_66 A1_66 A1_67 6.5385e-10
BA1_67 A1_67 MA_67 JJR area=1
CA1_67 A1_67 0 5.038e-16
LA1_67 A1_67 A1_68 6.5385e-10
BA1_68 A1_68 MA_68 JJR area=1
CA1_68 A1_68 0 5.038e-16
LA1_68 A1_68 A1_69 6.5385e-10
BA1_69 A1_69 MA_69 JJR area=1
CA1_69 A1_69 0 5.038e-16
LA1_69 A1_69 A1_70 6.5385e-10
BA1_70 A1_70 MA_70 JJR area=1
CA1_70 A1_70 0 5.038e-16
LA1_70 A1_70 A1_71 6.5385e-10
BA1_71 A1_71 MA_71 JJR area=1
CA1_71 A1_71 0 5.038e-16
LA1_71 A1_71 A1_72 6.5385e-10
BA1_72 A1_72 MA_72 JJR area=1
CA1_72 A1_72 0 5.038e-16
LA1_72 A1_72 A1_73 6.5385e-10
BA1_73 A1_73 MA_73 JJR area=1
CA1_73 A1_73 0 5.038e-16
LA1_73 A1_73 A1_74 6.5385e-10
BA1_74 A1_74 MA_74 JJR area=1
CA1_74 A1_74 0 5.038e-16
LA1_74 A1_74 A1_75 6.5385e-10
BA1_75 A1_75 MA_75 JJR area=1
CA1_75 A1_75 0 5.038e-16
LA1_75 A1_75 A1_76 6.5385e-10
BA1_76 A1_76 MA_76 JJR area=1
CA1_76 A1_76 0 5.038e-16
LA1_76 A1_76 A1_77 6.5385e-10
BA1_77 A1_77 MA_77 JJR area=1
CA1_77 A1_77 0 5.038e-16
LA1_77 A1_77 A1_78 6.5385e-10
BA1_78 A1_78 MA_78 JJR area=1
CA1_78 A1_78 0 5.038e-16
LA1_78 A1_78 A1_79 6.5385e-10
BA1_79 A1_79 MA_79 JJR area=1
CA1_79 A1_79 0 5.038e-16
LA1_79 A1_79 A1_80 6.5385e-10
BA1_80 A1_80 MA_80 JJR area=1
CA1_80 A1_80 0 5.038e-16
LA1_80 A1_80 A1_81 6.5385e-10
BA1_81 A1_81 MA_81 JJR area=1
CA1_81 A1_81 0 5.038e-16
LA1_81 A1_81 A1_82 6.5385e-10
BA1_82 A1_82 MA_82 JJR area=1
CA1_82 A1_82 0 5.038e-16
LA1_82 A1_82 A1_83 6.5385e-10
BA1_83 A1_83 MA_83 JJR area=1
CA1_83 A1_83 0 5.038e-16
LA1_83 A1_83 A1_84 6.5385e-10
BA1_84 A1_84 MA_84 JJR area=1
CA1_84 A1_84 0 5.038e-16
LA1_84 A1_84 A1_85 6.5385e-10
BA1_85 A1_85 MA_85 JJR area=1
CA1_85 A1_85 0 5.038e-16
LA1_85 A1_85 A1_86 6.5385e-10
BA1_86 A1_86 MA_86 JJR area=1
CA1_86 A1_86 0 5.038e-16
LA1_86 A1_86 A1_87 6.5385e-10
BA1_87 A1_87 MA_87 JJR area=1
CA1_87 A1_87 0 5.038e-16
LA1_87 A1_87 A1_88 6.5385e-10
BA1_88 A1_88 MA_88 JJR area=1
CA1_88 A1_88 0 5.038e-16
LA1_88 A1_88 A1_89 6.5385e-10
BA1_89 A1_89 MA_89 JJR area=1
CA1_89 A1_89 0 5.038e-16
LA1_89 A1_89 A1_90 6.5385e-10
BA1_90 A1_90 MA_90 JJR area=1
CA1_90 A1_90 0 5.038e-16
LA1_90 A1_90 A1_91 6.5385e-10
BA1_91 A1_91 0 JJR area=1
CA1_91 A1_91 0 5.038e-16
LA1_91 A1_91 A1_92 6.5385e-10
BA1_92 A1_92 0 JJR area=1
CA1_92 A1_92 0 5.038e-16
LA1_92 A1_92 A1_93 6.5385e-10
BA1_93 A1_93 0 JJR area=1
CA1_93 A1_93 0 5.038e-16
LA1_93 A1_93 A1_94 6.5385e-10
BA1_94 A1_94 0 JJR area=1
CA1_94 A1_94 0 5.038e-16
LA1_94 A1_94 A1_95 6.5385e-10
BA1_95 A1_95 0 JJR area=1
CA1_95 A1_95 0 5.038e-16
LA1_95 A1_95 A1_96 6.5385e-10
BA1_96 A1_96 0 JJR area=1
CA1_96 A1_96 0 5.038e-16
LA1_96 A1_96 A1_97 6.5385e-10
BA1_97 A1_97 0 JJR area=1
CA1_97 A1_97 0 5.038e-16
LA1_97 A1_97 A1_98 6.5385e-10
BA1_98 A1_98 0 JJR area=1
CA1_98 A1_98 0 5.038e-16
LA1_98 A1_98 A1_99 6.5385e-10
BA1_99 A1_99 0 JJR area=1
CA1_99 A1_99 0 5.038e-16
LA1_99 A1_99 A1_100 6.5385e-10
BA1_100 A1_100 0 JJR area=1
CA1_100 A1_100 0 5.038e-16
LA1_100 A1_100 A1_101 6.5385e-10
BA1_101 A1_101 0 JJR area=1
CA1_101 A1_101 0 5.038e-16
LA1_101 A1_101 A1_102 6.5385e-10
BA1_102 A1_102 0 JJR area=1
CA1_102 A1_102 0 5.038e-16
LA1_102 A1_102 A1_103 6.5385e-10
BA1_103 A1_103 0 JJR area=1
CA1_103 A1_103 0 5.038e-16
LA1_103 A1_103 A1_104 6.5385e-10
BA1_104 A1_104 0 JJR area=1
CA1_104 A1_104 0 5.038e-16
LA1_104 A1_104 A1_105 6.5385e-10
BA1_105 A1_105 0 JJR area=1
CA1_105 A1_105 0 5.038e-16
LA1_105 A1_105 A1_106 6.5385e-10
BA1_106 A1_106 0 JJR area=1
CA1_106 A1_106 0 5.038e-16
LA1_106 A1_106 A1_107 6.5385e-10
BA1_107 A1_107 0 JJR area=1
CA1_107 A1_107 0 5.038e-16
LA1_107 A1_107 A1_108 6.5385e-10
BA1_108 A1_108 0 JJR area=1
CA1_108 A1_108 0 5.038e-16
LA1_108 A1_108 A1_109 6.5385e-10
BA1_109 A1_109 0 JJR area=1
CA1_109 A1_109 0 5.038e-16
LA1_109 A1_109 A1_110 6.5385e-10
BA1_110 A1_110 0 JJR area=1
CA1_110 A1_110 0 5.038e-16
LA1_110 A1_110 A1_111 6.5384e-10
BA1_111 A1_111 SG_111 JJR area=1
CA1_111 A1_111 0 5.037e-16
LA1_111 A1_111 A1_112 6.5382e-10
BA1_112 A1_112 SG_112 JJR area=1
CA1_112 A1_112 0 5.031e-16
LA1_112 A1_112 A1_113 6.5377e-10
BA1_113 A1_113 SG_113 JJR area=1
CA1_113 A1_113 0 5.018e-16
LA1_113 A1_113 A1_114 6.5368e-10
BA1_114 A1_114 SG_114 JJR area=1
CA1_114 A1_114 0 4.998e-16
LA1_114 A1_114 A1_115 6.5356e-10
BA1_115 A1_115 SG_115 JJR area=1
CA1_115 A1_115 0 4.973e-16
LA1_115 A1_115 A1_116 6.534e-10
BA1_116 A1_116 SG_116 JJR area=1
CA1_116 A1_116 0 4.941e-16
LA1_116 A1_116 A1_117 6.5321e-10
BA1_117 A1_117 SG_117 JJR area=1
CA1_117 A1_117 0 4.903e-16
LA1_117 A1_117 A1_118 6.5299e-10
BA1_118 A1_118 SG_118 JJR area=1
CA1_118 A1_118 0 4.86e-16
LA1_118 A1_118 A1_119 6.5273e-10
BA1_119 A1_119 SG_119 JJR area=1
CA1_119 A1_119 0 4.811e-16
LA1_119 A1_119 A1_120 6.5245e-10
BA1_120 A1_120 SG_120 JJR area=1
CA1_120 A1_120 0 4.757e-16
LA1_120 A1_120 A1_121 6.5214e-10
BA1_121 A1_121 SG_121 JJR area=1
CA1_121 A1_121 0 4.698e-16
LA1_121 A1_121 A1_122 6.5181e-10
BA1_122 A1_122 SG_122 JJR area=1
CA1_122 A1_122 0 4.635e-16
LA1_122 A1_122 A1_123 6.5145e-10
BA1_123 A1_123 SG_123 JJR area=1
CA1_123 A1_123 0 4.567e-16
LA1_123 A1_123 A1_124 6.5107e-10
BA1_124 A1_124 SG_124 JJR area=1
CA1_124 A1_124 0 4.496e-16
LA1_124 A1_124 A1_125 6.5067e-10
BA1_125 A1_125 SG_125 JJR area=1
CA1_125 A1_125 0 4.422e-16
LA1_125 A1_125 A1_126 6.5026e-10
BA1_126 A1_126 SG_126 JJR area=1
CA1_126 A1_126 0 4.346e-16
LA1_126 A1_126 A1_127 6.4983e-10
BA1_127 A1_127 SG_127 JJR area=1
CA1_127 A1_127 0 4.267e-16
LA1_127 A1_127 A1_128 6.4939e-10
BA1_128 A1_128 SG_128 JJR area=1
CA1_128 A1_128 0 4.186e-16
LA1_128 A1_128 A1_129 6.4894e-10
BA1_129 A1_129 SG_129 JJR area=1
CA1_129 A1_129 0 4.104e-16
LA1_129 A1_129 A1_130 6.4849e-10
BA1_130 A1_130 SG_130 JJR area=1
CA1_130 A1_130 0 4.021e-16
LA1_130 A1_130 A1_131 6.4803e-10
BA1_131 A1_131 SG_131 JJR area=1
CA1_131 A1_131 0 3.938e-16
LA1_131 A1_131 A1_132 6.4758e-10
BA1_132 A1_132 SG_132 JJR area=1
CA1_132 A1_132 0 3.855e-16
LA1_132 A1_132 A1_133 6.4713e-10
BA1_133 A1_133 SG_133 JJR area=1
CA1_133 A1_133 0 3.772e-16
LA1_133 A1_133 A1_134 6.4668e-10
BA1_134 A1_134 SG_134 JJR area=1
CA1_134 A1_134 0 3.692e-16
LA1_134 A1_134 A1_135 6.4624e-10
BA1_135 A1_135 SG_135 JJR area=1
CA1_135 A1_135 0 3.613e-16
LA1_135 A1_135 A1_136 6.4581e-10
BA1_136 A1_136 SG_136 JJR area=1
CA1_136 A1_136 0 3.536e-16
LA1_136 A1_136 A1_137 6.454e-10
BA1_137 A1_137 SG_137 JJR area=1
CA1_137 A1_137 0 3.462e-16
LA1_137 A1_137 A1_138 6.45e-10
BA1_138 A1_138 SG_138 JJR area=1
CA1_138 A1_138 0 3.391e-16
LA1_138 A1_138 A1_139 6.4462e-10
BA1_139 A1_139 SG_139 JJR area=1
CA1_139 A1_139 0 3.324e-16
LA1_139 A1_139 A1_140 6.4426e-10
BA1_140 A1_140 SG_140 JJR area=1
CA1_140 A1_140 0 3.26e-16
LA1_140 A1_140 A1_141 6.4393e-10
BA1_141 A1_141 SG_141 JJR area=1
CA1_141 A1_141 0 3.201e-16
LA1_141 A1_141 A1_142 6.4362e-10
BA1_142 A1_142 SG_142 JJR area=1
CA1_142 A1_142 0 3.147e-16
LA1_142 A1_142 A1_143 6.4334e-10
BA1_143 A1_143 SG_143 JJR area=1
CA1_143 A1_143 0 3.099e-16
LA1_143 A1_143 A1_144 6.4308e-10
BA1_144 A1_144 SG_144 JJR area=1
CA1_144 A1_144 0 3.055e-16
LA1_144 A1_144 A1_145 6.4286e-10
BA1_145 A1_145 SG_145 JJR area=1
CA1_145 A1_145 0 3.017e-16
LA1_145 A1_145 A1_146 6.4267e-10
BA1_146 A1_146 SG_146 JJR area=1
CA1_146 A1_146 0 2.986e-16
LA1_146 A1_146 A1_147 6.4251e-10
BA1_147 A1_147 SG_147 JJR area=1
CA1_147 A1_147 0 2.96e-16
LA1_147 A1_147 A1_148 6.4239e-10
BA1_148 A1_148 SG_148 JJR area=1
CA1_148 A1_148 0 2.941e-16
LA1_148 A1_148 A1_149 6.423e-10
BA1_149 A1_149 SG_149 JJR area=1
CA1_149 A1_149 0 2.928e-16
LA1_149 A1_149 A1_150 6.4224e-10
BA1_150 A1_150 SG_150 JJR area=1
CA1_150 A1_150 0 2.921e-16
LA1_150 A1_150 A1_151 6.4222e-10
BA1_151 A1_151 SG_151 JJR area=1
CA1_151 A1_151 0 2.92e-16
LA1_151 A1_151 A1_152 6.4222e-10
BA1_152 A1_152 SG_152 JJR area=1
CA1_152 A1_152 0 2.92e-16
LA1_152 A1_152 A1_153 6.4222e-10
BA1_153 A1_153 SG_153 JJR area=1
CA1_153 A1_153 0 2.92e-16
LA1_153 A1_153 A1_154 6.4222e-10
BA1_154 A1_154 SG_154 JJR area=1
CA1_154 A1_154 0 2.92e-16
LA1_154 A1_154 A1_155 6.4222e-10
BA1_155 A1_155 SG_155 JJR area=1
CA1_155 A1_155 0 2.92e-16
LA1_155 A1_155 A1_156 6.4222e-10
BA1_156 A1_156 SG_156 JJR area=1
CA1_156 A1_156 0 2.92e-16
LA1_156 A1_156 A1_157 6.4222e-10
BA1_157 A1_157 SG_157 JJR area=1
CA1_157 A1_157 0 2.92e-16
LA1_157 A1_157 A1_158 6.4222e-10
BA1_158 A1_158 SG_158 JJR area=1
CA1_158 A1_158 0 2.92e-16
LA1_158 A1_158 A1_159 6.4222e-10
BA1_159 A1_159 SG_159 JJR area=1
CA1_159 A1_159 0 2.92e-16
LA1_159 A1_159 A1_160 6.4222e-10
BA1_160 A1_160 SG_160 JJR area=1
CA1_160 A1_160 0 2.92e-16
LA1_160 A1_160 A1_161 6.4222e-10
BA1_161 A1_161 SG_161 JJR area=1
CA1_161 A1_161 0 2.92e-16
LA1_161 A1_161 A1_162 6.4222e-10
BA1_162 A1_162 SG_162 JJR area=1
CA1_162 A1_162 0 2.92e-16
LA1_162 A1_162 A1_163 6.4222e-10
BA1_163 A1_163 SG_163 JJR area=1
CA1_163 A1_163 0 2.92e-16
LA1_163 A1_163 A1_164 6.4222e-10
BA1_164 A1_164 SG_164 JJR area=1
CA1_164 A1_164 0 2.92e-16
LA1_164 A1_164 A1_165 6.4222e-10
BA1_165 A1_165 SG_165 JJR area=1
CA1_165 A1_165 0 2.92e-16
LA1_165 A1_165 A1_166 6.4222e-10
BA1_166 A1_166 SG_166 JJR area=1
CA1_166 A1_166 0 2.92e-16
LA1_166 A1_166 A1_167 6.4222e-10
BA1_167 A1_167 SG_167 JJR area=1
CA1_167 A1_167 0 2.92e-16
LA1_167 A1_167 A1_168 6.4222e-10
BA1_168 A1_168 SG_168 JJR area=1
CA1_168 A1_168 0 2.92e-16
LA1_168 A1_168 A1_169 6.4222e-10
BA1_169 A1_169 SG_169 JJR area=1
CA1_169 A1_169 0 2.92e-16
LA1_169 A1_169 A1_170 6.4222e-10
BA1_170 A1_170 SG_170 JJR area=1
CA1_170 A1_170 0 2.92e-16
LA1_170 A1_170 A1_171 6.4222e-10
BA1_171 A1_171 SG_171 JJR area=1
CA1_171 A1_171 0 2.92e-16
LA1_171 A1_171 A1_172 6.4222e-10
BA1_172 A1_172 SG_172 JJR area=1
CA1_172 A1_172 0 2.92e-16
LA1_172 A1_172 A1_173 6.4222e-10
BA1_173 A1_173 SG_173 JJR area=1
CA1_173 A1_173 0 2.92e-16
LA1_173 A1_173 A1_174 6.4222e-10
BA1_174 A1_174 SG_174 JJR area=1
CA1_174 A1_174 0 2.92e-16
LA1_174 A1_174 A1_175 6.4222e-10
BA1_175 A1_175 SG_175 JJR area=1
CA1_175 A1_175 0 2.92e-16
LA1_175 A1_175 A1_176 6.4222e-10
BA1_176 A1_176 SG_176 JJR area=1
CA1_176 A1_176 0 2.92e-16
LA1_176 A1_176 A1_177 6.4222e-10
BA1_177 A1_177 SG_177 JJR area=1
CA1_177 A1_177 0 2.92e-16
LA1_177 A1_177 A1_178 6.4222e-10
BA1_178 A1_178 SG_178 JJR area=1
CA1_178 A1_178 0 2.92e-16
LA1_178 A1_178 A1_179 6.4222e-10
BA1_179 A1_179 SG_179 JJR area=1
CA1_179 A1_179 0 2.92e-16
LA1_179 A1_179 A1_180 6.4222e-10
BA1_180 A1_180 SG_180 JJR area=1
CA1_180 A1_180 0 2.92e-16
LA1_180 A1_180 A1_181 6.4222e-10
BA1_181 A1_181 SG_181 JJR area=1
CA1_181 A1_181 0 2.92e-16
LA1_181 A1_181 A1_182 6.4222e-10
BA1_182 A1_182 SG_182 JJR area=1
CA1_182 A1_182 0 2.92e-16
LA1_182 A1_182 A1_183 6.4222e-10
BA1_183 A1_183 SG_183 JJR area=1
CA1_183 A1_183 0 2.92e-16
LA1_183 A1_183 A1_184 6.4222e-10
BA1_184 A1_184 SG_184 JJR area=1
CA1_184 A1_184 0 2.92e-16
LA1_184 A1_184 A1_185 6.4222e-10
BA1_185 A1_185 SG_185 JJR area=1
CA1_185 A1_185 0 2.92e-16
LA1_185 A1_185 A1_186 6.4222e-10
BA1_186 A1_186 SG_186 JJR area=1
CA1_186 A1_186 0 2.92e-16
LA1_186 A1_186 A1_187 6.4222e-10
BA1_187 A1_187 SG_187 JJR area=1
CA1_187 A1_187 0 2.92e-16
LA1_187 A1_187 A1_188 6.4222e-10
BA1_188 A1_188 SG_188 JJR area=1
CA1_188 A1_188 0 2.92e-16
LA1_188 A1_188 A1_189 6.4222e-10
BA1_189 A1_189 SG_189 JJR area=1
CA1_189 A1_189 0 2.92e-16
LA1_189 A1_189 A1_190 6.4222e-10
BA1_190 A1_190 SG_190 JJR area=1
CA1_190 A1_190 0 2.92e-16
LA1_190 A1_190 A1_191 6.4222e-10
BA1_191 A1_191 SG_191 JJR area=1
CA1_191 A1_191 0 2.92e-16
LA1_191 A1_191 A1_192 6.4222e-10
BA1_192 A1_192 SG_192 JJR area=1
CA1_192 A1_192 0 2.92e-16
LA1_192 A1_192 A1_193 6.4222e-10
BA1_193 A1_193 SG_193 JJR area=1
CA1_193 A1_193 0 2.92e-16
LA1_193 A1_193 A1_194 6.4222e-10
BA1_194 A1_194 SG_194 JJR area=1
CA1_194 A1_194 0 2.92e-16
LA1_194 A1_194 A1_195 6.4222e-10
BA1_195 A1_195 SG_195 JJR area=1
CA1_195 A1_195 0 2.92e-16
LA1_195 A1_195 A1_196 6.4222e-10
BA1_196 A1_196 SG_196 JJR area=1
CA1_196 A1_196 0 2.92e-16
LA1_196 A1_196 A1_197 6.4222e-10
BA1_197 A1_197 SG_197 JJR area=1
CA1_197 A1_197 0 2.92e-16
LA1_197 A1_197 A1_198 6.4222e-10
BA1_198 A1_198 SG_198 JJR area=1
CA1_198 A1_198 0 2.92e-16
LA1_198 A1_198 A1_199 6.4222e-10
BA1_199 A1_199 SG_199 JJR area=1
CA1_199 A1_199 0 2.92e-16
LA1_199 A1_199 A1_200 6.4222e-10
BA1_200 A1_200 SG_200 JJR area=1
CA1_200 A1_200 0 2.92e-16
LA1_200 A1_200 A1_201 6.4222e-10
BA1_201 A1_201 SG_201 JJR area=1
CA1_201 A1_201 0 2.92e-16
LA1_201 A1_201 A1_202 6.4222e-10
BA1_202 A1_202 SG_202 JJR area=1
CA1_202 A1_202 0 2.92e-16
LA1_202 A1_202 A1_203 6.4222e-10
BA1_203 A1_203 SG_203 JJR area=1
CA1_203 A1_203 0 2.92e-16
LA1_203 A1_203 A1_204 6.4222e-10
BA1_204 A1_204 SG_204 JJR area=1
CA1_204 A1_204 0 2.92e-16
LA1_204 A1_204 A1_205 6.4222e-10
BA1_205 A1_205 SG_205 JJR area=1
CA1_205 A1_205 0 2.92e-16
LA1_205 A1_205 A1_206 6.4222e-10
BA1_206 A1_206 SG_206 JJR area=1
CA1_206 A1_206 0 2.92e-16
LA1_206 A1_206 A1_207 6.4222e-10
BA1_207 A1_207 SG_207 JJR area=1
CA1_207 A1_207 0 2.92e-16
LA1_207 A1_207 A1_208 6.4222e-10
BA1_208 A1_208 SG_208 JJR area=1
CA1_208 A1_208 0 2.92e-16
LA1_208 A1_208 A1_209 6.4222e-10
BA1_209 A1_209 SG_209 JJR area=1
CA1_209 A1_209 0 2.92e-16
LA1_209 A1_209 A1_210 6.4222e-10
BA1_210 A1_210 SG_210 JJR area=1
CA1_210 A1_210 0 2.92e-16
LA1_210 A1_210 A1_211 6.4222e-10
BA1_211 A1_211 SG_211 JJR area=1
CA1_211 A1_211 0 2.92e-16
LA1_211 A1_211 A1_212 6.4222e-10
BA1_212 A1_212 SG_212 JJR area=1
CA1_212 A1_212 0 2.92e-16
LA1_212 A1_212 A1_213 6.4222e-10
BA1_213 A1_213 SG_213 JJR area=1
CA1_213 A1_213 0 2.92e-16
LA1_213 A1_213 A1_214 6.4222e-10
BA1_214 A1_214 SG_214 JJR area=1
CA1_214 A1_214 0 2.92e-16
LA1_214 A1_214 A1_215 6.4222e-10
BA1_215 A1_215 SG_215 JJR area=1
CA1_215 A1_215 0 2.92e-16
LA1_215 A1_215 A1_216 6.4222e-10
BA1_216 A1_216 SG_216 JJR area=1
CA1_216 A1_216 0 2.92e-16
LA1_216 A1_216 A1_217 6.4222e-10
BA1_217 A1_217 SG_217 JJR area=1
CA1_217 A1_217 0 2.92e-16
LA1_217 A1_217 A1_218 6.4222e-10
BA1_218 A1_218 SG_218 JJR area=1
CA1_218 A1_218 0 2.92e-16
LA1_218 A1_218 A1_219 6.4222e-10
BA1_219 A1_219 SG_219 JJR area=1
CA1_219 A1_219 0 2.92e-16
LA1_219 A1_219 A1_220 6.4222e-10
BA1_220 A1_220 SG_220 JJR area=1
CA1_220 A1_220 0 2.92e-16
LA1_220 A1_220 A1_221 6.4222e-10
BA1_221 A1_221 SG_221 JJR area=1
CA1_221 A1_221 0 2.92e-16
LA1_221 A1_221 A1_222 6.4222e-10
BA1_222 A1_222 SG_222 JJR area=1
CA1_222 A1_222 0 2.92e-16
LA1_222 A1_222 A1_223 6.4222e-10
BA1_223 A1_223 SG_223 JJR area=1
CA1_223 A1_223 0 2.92e-16
LA1_223 A1_223 A1_224 6.4222e-10
BA1_224 A1_224 SG_224 JJR area=1
CA1_224 A1_224 0 2.92e-16
LA1_224 A1_224 A1_225 6.4222e-10
BA1_225 A1_225 SG_225 JJR area=1
CA1_225 A1_225 0 2.92e-16
LA1_225 A1_225 A1_226 6.4222e-10
BA1_226 A1_226 SG_226 JJR area=1
CA1_226 A1_226 0 2.92e-16
LA1_226 A1_226 A1_227 6.4222e-10
BA1_227 A1_227 SG_227 JJR area=1
CA1_227 A1_227 0 2.92e-16
LA1_227 A1_227 A1_228 6.4222e-10
BA1_228 A1_228 SG_228 JJR area=1
CA1_228 A1_228 0 2.92e-16
LA1_228 A1_228 A1_229 6.4222e-10
BA1_229 A1_229 SG_229 JJR area=1
CA1_229 A1_229 0 2.92e-16
LA1_229 A1_229 A1_230 6.4222e-10
BA1_230 A1_230 SG_230 JJR area=1
CA1_230 A1_230 0 2.92e-16
LA1_230 A1_230 A1_231 6.4222e-10
BA1_231 A1_231 SG_231 JJR area=1
CA1_231 A1_231 0 2.92e-16
LA1_231 A1_231 A1_232 6.4222e-10
BA1_232 A1_232 SG_232 JJR area=1
CA1_232 A1_232 0 2.92e-16
LA1_232 A1_232 A1_233 6.4222e-10
BA1_233 A1_233 SG_233 JJR area=1
CA1_233 A1_233 0 2.92e-16
LA1_233 A1_233 A1_234 6.4222e-10
BA1_234 A1_234 SG_234 JJR area=1
CA1_234 A1_234 0 2.92e-16
LA1_234 A1_234 A1_235 6.4222e-10
BA1_235 A1_235 SG_235 JJR area=1
CA1_235 A1_235 0 2.92e-16
LA1_235 A1_235 A1_236 6.4222e-10
BA1_236 A1_236 SG_236 JJR area=1
CA1_236 A1_236 0 2.92e-16
LA1_236 A1_236 A1_237 6.4222e-10
BA1_237 A1_237 SG_237 JJR area=1
CA1_237 A1_237 0 2.92e-16
LA1_237 A1_237 A1_238 6.4222e-10
BA1_238 A1_238 SG_238 JJR area=1
CA1_238 A1_238 0 2.92e-16
LA1_238 A1_238 A1_239 6.4222e-10
BA1_239 A1_239 SG_239 JJR area=1
CA1_239 A1_239 0 2.92e-16
LA1_239 A1_239 A1_240 6.4222e-10
BA1_240 A1_240 SG_240 JJR area=1
CA1_240 A1_240 0 2.92e-16
LA1_240 A1_240 A1_241 6.4222e-10
BA1_241 A1_241 SG_241 JJR area=1
CA1_241 A1_241 0 2.92e-16
LA1_241 A1_241 A1_242 6.4222e-10
BA1_242 A1_242 SG_242 JJR area=1
CA1_242 A1_242 0 2.92e-16
LA1_242 A1_242 A1_243 6.4222e-10
BA1_243 A1_243 SG_243 JJR area=1
CA1_243 A1_243 0 2.92e-16
LA1_243 A1_243 A1_244 6.4222e-10
BA1_244 A1_244 SG_244 JJR area=1
CA1_244 A1_244 0 2.92e-16
LA1_244 A1_244 A1_245 6.4222e-10
BA1_245 A1_245 SG_245 JJR area=1
CA1_245 A1_245 0 2.92e-16
LA1_245 A1_245 A1_246 6.4222e-10
BA1_246 A1_246 SG_246 JJR area=1
CA1_246 A1_246 0 2.92e-16
LA1_246 A1_246 A1_247 6.4222e-10
BA1_247 A1_247 SG_247 JJR area=1
CA1_247 A1_247 0 2.92e-16
LA1_247 A1_247 A1_248 6.4222e-10
BA1_248 A1_248 SG_248 JJR area=1
CA1_248 A1_248 0 2.92e-16
LA1_248 A1_248 A1_249 6.4222e-10
BA1_249 A1_249 SG_249 JJR area=1
CA1_249 A1_249 0 2.92e-16
LA1_249 A1_249 A1_250 6.4222e-10
BA1_250 A1_250 SG_250 JJR area=1
CA1_250 A1_250 0 2.92e-16
LA1_250 A1_250 A1_251 6.4222e-10
BA1_251 A1_251 SG_251 JJR area=1
CA1_251 A1_251 0 2.921e-16
LA1_251 A1_251 A1_252 6.4224e-10
BA1_252 A1_252 SG_252 JJR area=1
CA1_252 A1_252 0 2.928e-16
LA1_252 A1_252 A1_253 6.423e-10
BA1_253 A1_253 SG_253 JJR area=1
CA1_253 A1_253 0 2.941e-16
LA1_253 A1_253 A1_254 6.4239e-10
BA1_254 A1_254 SG_254 JJR area=1
CA1_254 A1_254 0 2.96e-16
LA1_254 A1_254 A1_255 6.4251e-10
BA1_255 A1_255 SG_255 JJR area=1
CA1_255 A1_255 0 2.986e-16
LA1_255 A1_255 A1_256 6.4267e-10
BA1_256 A1_256 SG_256 JJR area=1
CA1_256 A1_256 0 3.017e-16
LA1_256 A1_256 A1_257 6.4286e-10
BA1_257 A1_257 SG_257 JJR area=1
CA1_257 A1_257 0 3.055e-16
LA1_257 A1_257 A1_258 6.4308e-10
BA1_258 A1_258 SG_258 JJR area=1
CA1_258 A1_258 0 3.099e-16
LA1_258 A1_258 A1_259 6.4334e-10
BA1_259 A1_259 SG_259 JJR area=1
CA1_259 A1_259 0 3.147e-16
LA1_259 A1_259 A1_260 6.4362e-10
BA1_260 A1_260 SG_260 JJR area=1
CA1_260 A1_260 0 3.201e-16
LA1_260 A1_260 A1_261 6.4393e-10
BA1_261 A1_261 SG_261 JJR area=1
CA1_261 A1_261 0 3.26e-16
LA1_261 A1_261 A1_262 6.4426e-10
BA1_262 A1_262 SG_262 JJR area=1
CA1_262 A1_262 0 3.324e-16
LA1_262 A1_262 A1_263 6.4462e-10
BA1_263 A1_263 SG_263 JJR area=1
CA1_263 A1_263 0 3.391e-16
LA1_263 A1_263 A1_264 6.45e-10
BA1_264 A1_264 SG_264 JJR area=1
CA1_264 A1_264 0 3.462e-16
LA1_264 A1_264 A1_265 6.454e-10
BA1_265 A1_265 SG_265 JJR area=1
CA1_265 A1_265 0 3.536e-16
LA1_265 A1_265 A1_266 6.4581e-10
BA1_266 A1_266 SG_266 JJR area=1
CA1_266 A1_266 0 3.613e-16
LA1_266 A1_266 A1_267 6.4624e-10
BA1_267 A1_267 SG_267 JJR area=1
CA1_267 A1_267 0 3.692e-16
LA1_267 A1_267 A1_268 6.4668e-10
BA1_268 A1_268 SG_268 JJR area=1
CA1_268 A1_268 0 3.772e-16
LA1_268 A1_268 A1_269 6.4713e-10
BA1_269 A1_269 SG_269 JJR area=1
CA1_269 A1_269 0 3.855e-16
LA1_269 A1_269 A1_270 6.4758e-10
BA1_270 A1_270 SG_270 JJR area=1
CA1_270 A1_270 0 3.938e-16
LA1_270 A1_270 A1_271 6.4803e-10
BA1_271 A1_271 SG_271 JJR area=1
CA1_271 A1_271 0 4.021e-16
LA1_271 A1_271 A1_272 6.4849e-10
BA1_272 A1_272 SG_272 JJR area=1
CA1_272 A1_272 0 4.104e-16
LA1_272 A1_272 A1_273 6.4894e-10
BA1_273 A1_273 SG_273 JJR area=1
CA1_273 A1_273 0 4.186e-16
LA1_273 A1_273 A1_274 6.4939e-10
BA1_274 A1_274 SG_274 JJR area=1
CA1_274 A1_274 0 4.267e-16
LA1_274 A1_274 A1_275 6.4983e-10
BA1_275 A1_275 SG_275 JJR area=1
CA1_275 A1_275 0 4.346e-16
LA1_275 A1_275 A1_276 6.5026e-10
BA1_276 A1_276 SG_276 JJR area=1
CA1_276 A1_276 0 4.422e-16
LA1_276 A1_276 A1_277 6.5067e-10
BA1_277 A1_277 SG_277 JJR area=1
CA1_277 A1_277 0 4.496e-16
LA1_277 A1_277 A1_278 6.5107e-10
BA1_278 A1_278 SG_278 JJR area=1
CA1_278 A1_278 0 4.567e-16
LA1_278 A1_278 A1_279 6.5145e-10
BA1_279 A1_279 SG_279 JJR area=1
CA1_279 A1_279 0 4.635e-16
LA1_279 A1_279 A1_280 6.5181e-10
BA1_280 A1_280 SG_280 JJR area=1
CA1_280 A1_280 0 4.698e-16
LA1_280 A1_280 A1_281 6.5214e-10
BA1_281 A1_281 SG_281 JJR area=1
CA1_281 A1_281 0 4.757e-16
LA1_281 A1_281 A1_282 6.5245e-10
BA1_282 A1_282 SG_282 JJR area=1
CA1_282 A1_282 0 4.811e-16
LA1_282 A1_282 A1_283 6.5273e-10
BA1_283 A1_283 SG_283 JJR area=1
CA1_283 A1_283 0 4.86e-16
LA1_283 A1_283 A1_284 6.5299e-10
BA1_284 A1_284 SG_284 JJR area=1
CA1_284 A1_284 0 4.903e-16
LA1_284 A1_284 A1_285 6.5321e-10
BA1_285 A1_285 SG_285 JJR area=1
CA1_285 A1_285 0 4.941e-16
LA1_285 A1_285 A1_286 6.534e-10
BA1_286 A1_286 SG_286 JJR area=1
CA1_286 A1_286 0 4.973e-16
LA1_286 A1_286 A1_287 6.5356e-10
BA1_287 A1_287 SG_287 JJR area=1
CA1_287 A1_287 0 4.998e-16
LA1_287 A1_287 A1_288 6.5368e-10
BA1_288 A1_288 SG_288 JJR area=1
CA1_288 A1_288 0 5.018e-16
LA1_288 A1_288 A1_289 6.5377e-10
BA1_289 A1_289 SG_289 JJR area=1
CA1_289 A1_289 0 5.031e-16
LA1_289 A1_289 A1_290 6.5382e-10
BA1_290 A1_290 SG_290 JJR area=1
CA1_290 A1_290 0 5.037e-16
LA1_290 A1_290 A1_291 6.5384e-10
BA1_291 A1_291 0 JJR area=1
CA1_291 A1_291 0 5.038e-16
LA1_291 A1_291 A1_292 6.5385e-10
BA1_292 A1_292 0 JJR area=1
CA1_292 A1_292 0 5.038e-16
LA1_292 A1_292 A1_293 6.5385e-10
BA1_293 A1_293 0 JJR area=1
CA1_293 A1_293 0 5.038e-16
LA1_293 A1_293 A1_294 6.5385e-10
BA1_294 A1_294 0 JJR area=1
CA1_294 A1_294 0 5.038e-16
LA1_294 A1_294 A1_295 6.5385e-10
BA1_295 A1_295 0 JJR area=1
CA1_295 A1_295 0 5.038e-16
LA1_295 A1_295 A1_296 6.5385e-10
BA1_296 A1_296 0 JJR area=1
CA1_296 A1_296 0 5.038e-16
LA1_296 A1_296 A1_297 6.5385e-10
BA1_297 A1_297 0 JJR area=1
CA1_297 A1_297 0 5.038e-16
LA1_297 A1_297 A1_298 6.5385e-10
BA1_298 A1_298 0 JJR area=1
CA1_298 A1_298 0 5.038e-16
LA1_298 A1_298 A1_299 6.5385e-10
BA1_299 A1_299 0 JJR area=1
CA1_299 A1_299 0 5.038e-16
LA1_299 A1_299 A1_300 6.5385e-10
BA1_300 A1_300 0 JJR area=1
CA1_300 A1_300 0 5.038e-16
LA1_300 A1_300 A1_301 6.5385e-10
BA1_301 A1_301 0 JJR area=1
CA1_301 A1_301 0 5.038e-16
LA1_301 A1_301 A1_302 6.5385e-10
BA1_302 A1_302 0 JJR area=1
CA1_302 A1_302 0 5.038e-16
LA1_302 A1_302 A1_303 6.5385e-10
BA1_303 A1_303 0 JJR area=1
CA1_303 A1_303 0 5.038e-16
LA1_303 A1_303 A1_304 6.5385e-10
BA1_304 A1_304 0 JJR area=1
CA1_304 A1_304 0 5.038e-16
LA1_304 A1_304 A1_305 6.5385e-10
BA1_305 A1_305 0 JJR area=1
CA1_305 A1_305 0 5.038e-16
LA1_305 A1_305 A1_306 6.5385e-10
BA1_306 A1_306 0 JJR area=1
CA1_306 A1_306 0 5.038e-16
LA1_306 A1_306 A1_307 6.5385e-10
BA1_307 A1_307 0 JJR area=1
CA1_307 A1_307 0 5.038e-16
LA1_307 A1_307 A1_308 6.5385e-10
BA1_308 A1_308 0 JJR area=1
CA1_308 A1_308 0 5.038e-16
LA1_308 A1_308 A1_309 6.5385e-10
BA1_309 A1_309 0 JJR area=1
CA1_309 A1_309 0 5.038e-16
LA1_309 A1_309 A1_310 6.5385e-10
BA1_310 A1_310 0 JJR area=1
CA1_310 A1_310 0 5.038e-16
LA1_310 A1_310 A1_311 6.5385e-10
BA1_311 A1_311 MA_311 JJR area=1
CA1_311 A1_311 0 5.038e-16
LA1_311 A1_311 A1_312 6.5385e-10
BA1_312 A1_312 MA_312 JJR area=1
CA1_312 A1_312 0 5.038e-16
LA1_312 A1_312 A1_313 6.5385e-10
BA1_313 A1_313 MA_313 JJR area=1
CA1_313 A1_313 0 5.038e-16
LA1_313 A1_313 A1_314 6.5385e-10
BA1_314 A1_314 MA_314 JJR area=1
CA1_314 A1_314 0 5.038e-16
LA1_314 A1_314 A1_315 6.5385e-10
BA1_315 A1_315 MA_315 JJR area=1
CA1_315 A1_315 0 5.038e-16
LA1_315 A1_315 A1_316 6.5385e-10
BA1_316 A1_316 MA_316 JJR area=1
CA1_316 A1_316 0 5.038e-16
LA1_316 A1_316 A1_317 6.5385e-10
BA1_317 A1_317 MA_317 JJR area=1
CA1_317 A1_317 0 5.038e-16
LA1_317 A1_317 A1_318 6.5385e-10
BA1_318 A1_318 MA_318 JJR area=1
CA1_318 A1_318 0 5.038e-16
LA1_318 A1_318 A1_319 6.5385e-10
BA1_319 A1_319 MA_319 JJR area=1
CA1_319 A1_319 0 5.038e-16
LA1_319 A1_319 A1_320 6.5385e-10
BA1_320 A1_320 MA_320 JJR area=1
CA1_320 A1_320 0 5.038e-16
LA1_320 A1_320 A1_321 6.5385e-10
BA1_321 A1_321 MA_321 JJR area=1
CA1_321 A1_321 0 5.038e-16
LA1_321 A1_321 A1_322 6.5385e-10
BA1_322 A1_322 MA_322 JJR area=1
CA1_322 A1_322 0 5.038e-16
LA1_322 A1_322 A1_323 6.5385e-10
BA1_323 A1_323 MA_323 JJR area=1
CA1_323 A1_323 0 5.038e-16
LA1_323 A1_323 A1_324 6.5385e-10
BA1_324 A1_324 MA_324 JJR area=1
CA1_324 A1_324 0 5.038e-16
LA1_324 A1_324 A1_325 6.5385e-10
BA1_325 A1_325 MA_325 JJR area=1
CA1_325 A1_325 0 5.038e-16
LA1_325 A1_325 A1_326 6.5385e-10
BA1_326 A1_326 MA_326 JJR area=1
CA1_326 A1_326 0 5.038e-16
LA1_326 A1_326 A1_327 6.5385e-10
BA1_327 A1_327 MA_327 JJR area=1
CA1_327 A1_327 0 5.038e-16
LA1_327 A1_327 A1_328 6.5385e-10
BA1_328 A1_328 MA_328 JJR area=1
CA1_328 A1_328 0 5.038e-16
LA1_328 A1_328 A1_329 6.5385e-10
BA1_329 A1_329 MA_329 JJR area=1
CA1_329 A1_329 0 5.038e-16
LA1_329 A1_329 A1_330 6.5385e-10
BA1_330 A1_330 MA_330 JJR area=1
CA1_330 A1_330 0 5.038e-16
LA1_330 A1_330 A1_331 6.5385e-10
BA1_331 A1_331 MA_331 JJR area=1
CA1_331 A1_331 0 5.038e-16
LA1_331 A1_331 A1_332 6.5385e-10
BA1_332 A1_332 MA_332 JJR area=1
CA1_332 A1_332 0 5.038e-16
LA1_332 A1_332 A1_333 6.5385e-10
BA1_333 A1_333 MA_333 JJR area=1
CA1_333 A1_333 0 5.038e-16
LA1_333 A1_333 A1_334 6.5385e-10
BA1_334 A1_334 MA_334 JJR area=1
CA1_334 A1_334 0 5.038e-16
LA1_334 A1_334 A1_335 6.5385e-10
BA1_335 A1_335 MA_335 JJR area=1
CA1_335 A1_335 0 5.038e-16
LA1_335 A1_335 A1_336 6.5385e-10
BA1_336 A1_336 MA_336 JJR area=1
CA1_336 A1_336 0 5.038e-16
LA1_336 A1_336 A1_337 6.5385e-10
BA1_337 A1_337 MA_337 JJR area=1
CA1_337 A1_337 0 5.038e-16
LA1_337 A1_337 A1_338 6.5385e-10
BA1_338 A1_338 MA_338 JJR area=1
CA1_338 A1_338 0 5.038e-16
LA1_338 A1_338 A1_339 6.5385e-10
BA1_339 A1_339 MA_339 JJR area=1
CA1_339 A1_339 0 5.038e-16
LA1_339 A1_339 A1_340 6.5385e-10
BA1_340 A1_340 MA_340 JJR area=1
CA1_340 A1_340 0 5.038e-16
LA1_340 A1_340 A1_341 6.5385e-10
BA1_341 A1_341 MA_341 JJR area=1
CA1_341 A1_341 0 5.038e-16
LA1_341 A1_341 A1_342 6.5385e-10
BA1_342 A1_342 MA_342 JJR area=1
CA1_342 A1_342 0 5.038e-16
LA1_342 A1_342 A1_343 6.5385e-10
BA1_343 A1_343 MA_343 JJR area=1
CA1_343 A1_343 0 5.038e-16
LA1_343 A1_343 A1_344 6.5385e-10
BA1_344 A1_344 MA_344 JJR area=1
CA1_344 A1_344 0 5.038e-16
LA1_344 A1_344 A1_345 6.5385e-10
BA1_345 A1_345 MA_345 JJR area=1
CA1_345 A1_345 0 5.038e-16
LA1_345 A1_345 A1_346 6.5385e-10
BA1_346 A1_346 MA_346 JJR area=1
CA1_346 A1_346 0 5.038e-16
LA1_346 A1_346 A1_347 6.5385e-10
BA1_347 A1_347 MA_347 JJR area=1
CA1_347 A1_347 0 5.038e-16
LA1_347 A1_347 A1_348 6.5385e-10
BA1_348 A1_348 MA_348 JJR area=1
CA1_348 A1_348 0 5.038e-16
LA1_348 A1_348 A1_349 6.5385e-10
BA1_349 A1_349 MA_349 JJR area=1
CA1_349 A1_349 0 5.038e-16
LA1_349 A1_349 A1_350 6.5385e-10
BA1_350 A1_350 MA_350 JJR area=1
CA1_350 A1_350 0 5.038e-16
LA1_350 A1_350 A1_351 6.5385e-10
BA1_351 A1_351 MA_351 JJR area=1
CA1_351 A1_351 0 5.038e-16
LA1_351 A1_351 A1_352 6.5385e-10
BA1_352 A1_352 0 JJR area=1
CA1_352 A1_352 0 5.038e-16
LA1_352 A1_352 A1_353 6.5385e-10
BA1_353 A1_353 0 JJR area=1
CA1_353 A1_353 0 5.038e-16
LA1_353 A1_353 A1_354 6.5385e-10
BA1_354 A1_354 0 JJR area=1
CA1_354 A1_354 0 5.038e-16
LA1_354 A1_354 A1_355 6.5385e-10
BA1_355 A1_355 0 JJR area=1
CA1_355 A1_355 0 5.038e-16
LA1_355 A1_355 A1_356 6.5385e-10
BA1_356 A1_356 0 JJR area=1
CA1_356 A1_356 0 5.038e-16
LA1_356 A1_356 A1_357 6.5385e-10
BA1_357 A1_357 0 JJR area=1
CA1_357 A1_357 0 5.038e-16
LA1_357 A1_357 A1_358 6.5385e-10
BA1_358 A1_358 0 JJR area=1
CA1_358 A1_358 0 5.038e-16
LA1_358 A1_358 A1_359 6.5385e-10
BA1_359 A1_359 0 JJR area=1
CA1_359 A1_359 0 5.038e-16
LA1_359 A1_359 A1_360 6.5385e-10
BA1_360 A1_360 0 JJR area=1
CA1_360 A1_360 0 5.038e-16
LA1_360 A1_360 A1_361 6.5385e-10
BA1_361 A1_361 0 JJR area=1
CA1_361 A1_361 0 5.038e-16
BINJ_A1 A1_0 0 JJI area=1
IINJ_A1 0 A1_0 pwl(0 0 20p 0 30p 1.933e-07 50p 0)
LCATCH_A1 A1_361 0 20n
IACC_A1_10 0 A1_10 pwl(0 0 50p 0 60p 4.027e-09 200p 4.027e-09 210p 0)
IACC_A1_11 0 A1_11 pwl(0 0 50p 0 60p 4.027e-09 200p 4.027e-09 210p 0)
IACC_A1_12 0 A1_12 pwl(0 0 50p 0 60p 4.027e-09 200p 4.027e-09 210p 0)
IACC_A1_13 0 A1_13 pwl(0 0 50p 0 60p 4.027e-09 200p 4.027e-09 210p 0)
IACC_A1_14 0 A1_14 pwl(0 0 50p 0 60p 4.027e-09 200p 4.027e-09 210p 0)
IACC_A1_15 0 A1_15 pwl(0 0 50p 0 60p 4.027e-09 200p 4.027e-09 210p 0)
IACC_A1_16 0 A1_16 pwl(0 0 50p 0 60p 4.027e-09 200p 4.027e-09 210p 0)
IACC_A1_17 0 A1_17 pwl(0 0 50p 0 60p 4.027e-09 200p 4.027e-09 210p 0)
IACC_A1_18 0 A1_18 pwl(0 0 50p 0 60p 4.027e-09 200p 4.027e-09 210p 0)
IACC_A1_19 0 A1_19 pwl(0 0 50p 0 60p 4.027e-09 200p 4.027e-09 210p 0)
IACC_A1_20 0 A1_20 pwl(0 0 50p 0 60p 4.027e-09 200p 4.027e-09 210p 0)
IACC_A1_21 0 A1_21 pwl(0 0 50p 0 60p 4.027e-09 200p 4.027e-09 210p 0)
IACC_A1_22 0 A1_22 pwl(0 0 50p 0 60p 4.027e-09 200p 4.027e-09 210p 0)
IACC_A1_23 0 A1_23 pwl(0 0 50p 0 60p 4.027e-09 200p 4.027e-09 210p 0)
IACC_A1_24 0 A1_24 pwl(0 0 50p 0 60p 4.027e-09 200p 4.027e-09 210p 0)
IACC_A1_25 0 A1_25 pwl(0 0 50p 0 60p 4.027e-09 200p 4.027e-09 210p 0)
IACC_A1_26 0 A1_26 pwl(0 0 50p 0 60p 4.027e-09 200p 4.027e-09 210p 0)
IACC_A1_27 0 A1_27 pwl(0 0 50p 0 60p 4.027e-09 200p 4.027e-09 210p 0)
IACC_A1_28 0 A1_28 pwl(0 0 50p 0 60p 4.027e-09 200p 4.027e-09 210p 0)
IACC_A1_29 0 A1_29 pwl(0 0 50p 0 60p 4.027e-09 200p 4.027e-09 210p 0)
IACC_A1_30 0 A1_30 pwl(0 0 50p 0 60p 4.027e-09 200p 4.027e-09 210p 0)
IACC_A1_31 0 A1_31 pwl(0 0 50p 0 60p 4.027e-09 200p 4.027e-09 210p 0)
IACC_A1_32 0 A1_32 pwl(0 0 50p 0 60p 4.027e-09 200p 4.027e-09 210p 0)
IACC_A1_33 0 A1_33 pwl(0 0 50p 0 60p 4.027e-09 200p 4.027e-09 210p 0)
IACC_A1_34 0 A1_34 pwl(0 0 50p 0 60p 4.027e-09 200p 4.027e-09 210p 0)
IACC_A1_35 0 A1_35 pwl(0 0 50p 0 60p 4.027e-09 200p 4.027e-09 210p 0)
IACC_A1_36 0 A1_36 pwl(0 0 50p 0 60p 4.027e-09 200p 4.027e-09 210p 0)
IACC_A1_37 0 A1_37 pwl(0 0 50p 0 60p 4.027e-09 200p 4.027e-09 210p 0)
IACC_A1_38 0 A1_38 pwl(0 0 50p 0 60p 4.027e-09 200p 4.027e-09 210p 0)
IACC_A1_39 0 A1_39 pwl(0 0 50p 0 60p 4.027e-09 200p 4.027e-09 210p 0)
IACC_A1_40 0 A1_40 pwl(0 0 50p 0 60p 4.027e-09 200p 4.027e-09 210p 0)
IACC_A1_41 0 A1_41 pwl(0 0 50p 0 60p 4.027e-09 200p 4.027e-09 210p 0)
IACC_A1_42 0 A1_42 pwl(0 0 50p 0 60p 4.027e-09 200p 4.027e-09 210p 0)
IACC_A1_43 0 A1_43 pwl(0 0 50p 0 60p 4.027e-09 200p 4.027e-09 210p 0)
IACC_A1_44 0 A1_44 pwl(0 0 50p 0 60p 4.027e-09 200p 4.027e-09 210p 0)
IACC_A1_45 0 A1_45 pwl(0 0 50p 0 60p 4.027e-09 200p 4.027e-09 210p 0)
IACC_A1_46 0 A1_46 pwl(0 0 50p 0 60p 4.027e-09 200p 4.027e-09 210p 0)
IACC_A1_47 0 A1_47 pwl(0 0 50p 0 60p 4.027e-09 200p 4.027e-09 210p 0)
IACC_A1_48 0 A1_48 pwl(0 0 50p 0 60p 4.027e-09 200p 4.027e-09 210p 0)
IACC_A1_49 0 A1_49 pwl(0 0 50p 0 60p 4.027e-09 200p 4.027e-09 210p 0)
BB1_0 B1_0 0 JJR area=1
CB1_0 B1_0 0 5.038e-16
LB1_0 B1_0 B1_1 6.5385e-10
BB1_1 B1_1 0 JJR area=1
CB1_1 B1_1 0 5.038e-16
LB1_1 B1_1 B1_2 6.5385e-10
BB1_2 B1_2 0 JJR area=1
CB1_2 B1_2 0 5.038e-16
LB1_2 B1_2 B1_3 6.5385e-10
BB1_3 B1_3 0 JJR area=1
CB1_3 B1_3 0 5.038e-16
LB1_3 B1_3 B1_4 6.5385e-10
BB1_4 B1_4 0 JJR area=1
CB1_4 B1_4 0 5.038e-16
LB1_4 B1_4 B1_5 6.5385e-10
BB1_5 B1_5 0 JJR area=1
CB1_5 B1_5 0 5.038e-16
LB1_5 B1_5 B1_6 6.5385e-10
BB1_6 B1_6 0 JJR area=1
CB1_6 B1_6 0 5.038e-16
LB1_6 B1_6 B1_7 6.5385e-10
BB1_7 B1_7 0 JJR area=1
CB1_7 B1_7 0 5.038e-16
LB1_7 B1_7 B1_8 6.5385e-10
BB1_8 B1_8 0 JJR area=1
CB1_8 B1_8 0 5.038e-16
LB1_8 B1_8 B1_9 6.5385e-10
BB1_9 B1_9 0 JJR area=1
CB1_9 B1_9 0 5.038e-16
LB1_9 B1_9 B1_10 6.5385e-10
BB1_10 B1_10 MB_10 JJR area=1
CB1_10 B1_10 0 5.038e-16
LB1_10 B1_10 B1_11 6.5385e-10
BB1_11 B1_11 MB_11 JJR area=1
CB1_11 B1_11 0 5.038e-16
LB1_11 B1_11 B1_12 6.5385e-10
BB1_12 B1_12 MB_12 JJR area=1
CB1_12 B1_12 0 5.038e-16
LB1_12 B1_12 B1_13 6.5385e-10
BB1_13 B1_13 MB_13 JJR area=1
CB1_13 B1_13 0 5.038e-16
LB1_13 B1_13 B1_14 6.5385e-10
BB1_14 B1_14 MB_14 JJR area=1
CB1_14 B1_14 0 5.038e-16
LB1_14 B1_14 B1_15 6.5385e-10
BB1_15 B1_15 MB_15 JJR area=1
CB1_15 B1_15 0 5.038e-16
LB1_15 B1_15 B1_16 6.5385e-10
BB1_16 B1_16 MB_16 JJR area=1
CB1_16 B1_16 0 5.038e-16
LB1_16 B1_16 B1_17 6.5385e-10
BB1_17 B1_17 MB_17 JJR area=1
CB1_17 B1_17 0 5.038e-16
LB1_17 B1_17 B1_18 6.5385e-10
BB1_18 B1_18 MB_18 JJR area=1
CB1_18 B1_18 0 5.038e-16
LB1_18 B1_18 B1_19 6.5385e-10
BB1_19 B1_19 MB_19 JJR area=1
CB1_19 B1_19 0 5.038e-16
LB1_19 B1_19 B1_20 6.5385e-10
BB1_20 B1_20 MB_20 JJR area=1
CB1_20 B1_20 0 5.038e-16
LB1_20 B1_20 B1_21 6.5385e-10
BB1_21 B1_21 MB_21 JJR area=1
CB1_21 B1_21 0 5.038e-16
LB1_21 B1_21 B1_22 6.5385e-10
BB1_22 B1_22 MB_22 JJR area=1
CB1_22 B1_22 0 5.038e-16
LB1_22 B1_22 B1_23 6.5385e-10
BB1_23 B1_23 MB_23 JJR area=1
CB1_23 B1_23 0 5.038e-16
LB1_23 B1_23 B1_24 6.5385e-10
BB1_24 B1_24 MB_24 JJR area=1
CB1_24 B1_24 0 5.038e-16
LB1_24 B1_24 B1_25 6.5385e-10
BB1_25 B1_25 MB_25 JJR area=1
CB1_25 B1_25 0 5.038e-16
LB1_25 B1_25 B1_26 6.5385e-10
BB1_26 B1_26 MB_26 JJR area=1
CB1_26 B1_26 0 5.038e-16
LB1_26 B1_26 B1_27 6.5385e-10
BB1_27 B1_27 MB_27 JJR area=1
CB1_27 B1_27 0 5.038e-16
LB1_27 B1_27 B1_28 6.5385e-10
BB1_28 B1_28 MB_28 JJR area=1
CB1_28 B1_28 0 5.038e-16
LB1_28 B1_28 B1_29 6.5385e-10
BB1_29 B1_29 MB_29 JJR area=1
CB1_29 B1_29 0 5.038e-16
LB1_29 B1_29 B1_30 6.5385e-10
BB1_30 B1_30 MB_30 JJR area=1
CB1_30 B1_30 0 5.038e-16
LB1_30 B1_30 B1_31 6.5385e-10
BB1_31 B1_31 MB_31 JJR area=1
CB1_31 B1_31 0 5.038e-16
LB1_31 B1_31 B1_32 6.5385e-10
BB1_32 B1_32 MB_32 JJR area=1
CB1_32 B1_32 0 5.038e-16
LB1_32 B1_32 B1_33 6.5385e-10
BB1_33 B1_33 MB_33 JJR area=1
CB1_33 B1_33 0 5.038e-16
LB1_33 B1_33 B1_34 6.5385e-10
BB1_34 B1_34 MB_34 JJR area=1
CB1_34 B1_34 0 5.038e-16
LB1_34 B1_34 B1_35 6.5385e-10
BB1_35 B1_35 MB_35 JJR area=1
CB1_35 B1_35 0 5.038e-16
LB1_35 B1_35 B1_36 6.5385e-10
BB1_36 B1_36 MB_36 JJR area=1
CB1_36 B1_36 0 5.038e-16
LB1_36 B1_36 B1_37 6.5385e-10
BB1_37 B1_37 MB_37 JJR area=1
CB1_37 B1_37 0 5.038e-16
LB1_37 B1_37 B1_38 6.5385e-10
BB1_38 B1_38 MB_38 JJR area=1
CB1_38 B1_38 0 5.038e-16
LB1_38 B1_38 B1_39 6.5385e-10
BB1_39 B1_39 MB_39 JJR area=1
CB1_39 B1_39 0 5.038e-16
LB1_39 B1_39 B1_40 6.5385e-10
BB1_40 B1_40 MB_40 JJR area=1
CB1_40 B1_40 0 5.038e-16
LB1_40 B1_40 B1_41 6.5385e-10
BB1_41 B1_41 MB_41 JJR area=1
CB1_41 B1_41 0 5.038e-16
LB1_41 B1_41 B1_42 6.5385e-10
BB1_42 B1_42 MB_42 JJR area=1
CB1_42 B1_42 0 5.038e-16
LB1_42 B1_42 B1_43 6.5385e-10
BB1_43 B1_43 MB_43 JJR area=1
CB1_43 B1_43 0 5.038e-16
LB1_43 B1_43 B1_44 6.5385e-10
BB1_44 B1_44 MB_44 JJR area=1
CB1_44 B1_44 0 5.038e-16
LB1_44 B1_44 B1_45 6.5385e-10
BB1_45 B1_45 MB_45 JJR area=1
CB1_45 B1_45 0 5.038e-16
LB1_45 B1_45 B1_46 6.5385e-10
BB1_46 B1_46 MB_46 JJR area=1
CB1_46 B1_46 0 5.038e-16
LB1_46 B1_46 B1_47 6.5385e-10
BB1_47 B1_47 MB_47 JJR area=1
CB1_47 B1_47 0 5.038e-16
LB1_47 B1_47 B1_48 6.5385e-10
BB1_48 B1_48 MB_48 JJR area=1
CB1_48 B1_48 0 5.038e-16
LB1_48 B1_48 B1_49 6.5385e-10
BB1_49 B1_49 MB_49 JJR area=1
CB1_49 B1_49 0 5.038e-16
LB1_49 B1_49 B1_50 6.5385e-10
BB1_50 B1_50 MB_50 JJR area=1
CB1_50 B1_50 0 5.038e-16
LB1_50 B1_50 B1_51 6.5385e-10
BB1_51 B1_51 0 JJR area=1
CB1_51 B1_51 0 5.038e-16
LB1_51 B1_51 B1_52 6.5385e-10
BB1_52 B1_52 0 JJR area=1
CB1_52 B1_52 0 5.038e-16
LB1_52 B1_52 B1_53 6.5385e-10
BB1_53 B1_53 0 JJR area=1
CB1_53 B1_53 0 5.038e-16
LB1_53 B1_53 B1_54 6.5385e-10
BB1_54 B1_54 0 JJR area=1
CB1_54 B1_54 0 5.038e-16
LB1_54 B1_54 B1_55 6.5385e-10
BB1_55 B1_55 0 JJR area=1
CB1_55 B1_55 0 5.038e-16
LB1_55 B1_55 B1_56 6.5385e-10
BB1_56 B1_56 0 JJR area=1
CB1_56 B1_56 0 5.038e-16
LB1_56 B1_56 B1_57 6.5385e-10
BB1_57 B1_57 0 JJR area=1
CB1_57 B1_57 0 5.038e-16
LB1_57 B1_57 B1_58 6.5385e-10
BB1_58 B1_58 0 JJR area=1
CB1_58 B1_58 0 5.038e-16
LB1_58 B1_58 B1_59 6.5385e-10
BB1_59 B1_59 0 JJR area=1
CB1_59 B1_59 0 5.038e-16
LB1_59 B1_59 B1_60 6.5385e-10
BB1_60 B1_60 0 JJR area=1
CB1_60 B1_60 0 5.038e-16
LB1_60 B1_60 B1_61 6.5385e-10
BB1_61 B1_61 0 JJR area=1
CB1_61 B1_61 0 5.038e-16
LB1_61 B1_61 B1_62 6.5385e-10
BB1_62 B1_62 0 JJR area=1
CB1_62 B1_62 0 5.038e-16
LB1_62 B1_62 B1_63 6.5385e-10
BB1_63 B1_63 0 JJR area=1
CB1_63 B1_63 0 5.038e-16
LB1_63 B1_63 B1_64 6.5385e-10
BB1_64 B1_64 0 JJR area=1
CB1_64 B1_64 0 5.038e-16
LB1_64 B1_64 B1_65 6.5385e-10
BB1_65 B1_65 0 JJR area=1
CB1_65 B1_65 0 5.038e-16
LB1_65 B1_65 B1_66 6.5385e-10
BB1_66 B1_66 0 JJR area=1
CB1_66 B1_66 0 5.038e-16
LB1_66 B1_66 B1_67 6.5385e-10
BB1_67 B1_67 0 JJR area=1
CB1_67 B1_67 0 5.038e-16
LB1_67 B1_67 B1_68 6.5385e-10
BB1_68 B1_68 0 JJR area=1
CB1_68 B1_68 0 5.038e-16
LB1_68 B1_68 B1_69 6.5385e-10
BB1_69 B1_69 0 JJR area=1
CB1_69 B1_69 0 5.038e-16
LB1_69 B1_69 B1_70 6.5385e-10
BB1_70 B1_70 0 JJR area=1
CB1_70 B1_70 0 5.038e-16
LB1_70 B1_70 B1_71 6.5385e-10
BB1_71 B1_71 0 JJR area=1
CB1_71 B1_71 0 5.038e-16
LB1_71 B1_71 B1_72 6.5385e-10
BB1_72 B1_72 0 JJR area=1
CB1_72 B1_72 0 5.038e-16
LB1_72 B1_72 B1_73 6.5385e-10
BB1_73 B1_73 0 JJR area=1
CB1_73 B1_73 0 5.038e-16
LB1_73 B1_73 B1_74 6.5385e-10
BB1_74 B1_74 0 JJR area=1
CB1_74 B1_74 0 5.038e-16
LB1_74 B1_74 B1_75 6.5385e-10
BB1_75 B1_75 0 JJR area=1
CB1_75 B1_75 0 5.038e-16
LB1_75 B1_75 B1_76 6.5385e-10
BB1_76 B1_76 0 JJR area=1
CB1_76 B1_76 0 5.038e-16
LB1_76 B1_76 B1_77 6.5385e-10
BB1_77 B1_77 0 JJR area=1
CB1_77 B1_77 0 5.038e-16
LB1_77 B1_77 B1_78 6.5385e-10
BB1_78 B1_78 0 JJR area=1
CB1_78 B1_78 0 5.038e-16
LB1_78 B1_78 B1_79 6.5385e-10
BB1_79 B1_79 0 JJR area=1
CB1_79 B1_79 0 5.038e-16
LB1_79 B1_79 B1_80 6.5385e-10
BB1_80 B1_80 0 JJR area=1
CB1_80 B1_80 0 5.038e-16
LB1_80 B1_80 B1_81 6.5385e-10
BB1_81 B1_81 0 JJR area=1
CB1_81 B1_81 0 5.038e-16
LB1_81 B1_81 B1_82 6.5385e-10
BB1_82 B1_82 0 JJR area=1
CB1_82 B1_82 0 5.038e-16
LB1_82 B1_82 B1_83 6.5385e-10
BB1_83 B1_83 0 JJR area=1
CB1_83 B1_83 0 5.038e-16
LB1_83 B1_83 B1_84 6.5385e-10
BB1_84 B1_84 0 JJR area=1
CB1_84 B1_84 0 5.038e-16
LB1_84 B1_84 B1_85 6.5385e-10
BB1_85 B1_85 0 JJR area=1
CB1_85 B1_85 0 5.038e-16
LB1_85 B1_85 B1_86 6.5385e-10
BB1_86 B1_86 0 JJR area=1
CB1_86 B1_86 0 5.038e-16
LB1_86 B1_86 B1_87 6.5385e-10
BB1_87 B1_87 0 JJR area=1
CB1_87 B1_87 0 5.038e-16
LB1_87 B1_87 B1_88 6.5385e-10
BB1_88 B1_88 0 JJR area=1
CB1_88 B1_88 0 5.038e-16
LB1_88 B1_88 B1_89 6.5385e-10
BB1_89 B1_89 0 JJR area=1
CB1_89 B1_89 0 5.038e-16
LB1_89 B1_89 B1_90 6.5385e-10
BB1_90 B1_90 0 JJR area=1
CB1_90 B1_90 0 5.038e-16
LB1_90 B1_90 B1_91 6.5385e-10
BB1_91 B1_91 0 JJR area=1
CB1_91 B1_91 0 5.038e-16
LB1_91 B1_91 B1_92 6.5385e-10
BB1_92 B1_92 0 JJR area=1
CB1_92 B1_92 0 5.038e-16
LB1_92 B1_92 B1_93 6.5385e-10
BB1_93 B1_93 0 JJR area=1
CB1_93 B1_93 0 5.038e-16
LB1_93 B1_93 B1_94 6.5385e-10
BB1_94 B1_94 0 JJR area=1
CB1_94 B1_94 0 5.038e-16
LB1_94 B1_94 B1_95 6.5385e-10
BB1_95 B1_95 0 JJR area=1
CB1_95 B1_95 0 5.038e-16
LB1_95 B1_95 B1_96 6.5385e-10
BB1_96 B1_96 0 JJR area=1
CB1_96 B1_96 0 5.038e-16
LB1_96 B1_96 B1_97 6.5385e-10
BB1_97 B1_97 0 JJR area=1
CB1_97 B1_97 0 5.038e-16
LB1_97 B1_97 B1_98 6.5385e-10
BB1_98 B1_98 0 JJR area=1
CB1_98 B1_98 0 5.038e-16
LB1_98 B1_98 B1_99 6.5385e-10
BB1_99 B1_99 0 JJR area=1
CB1_99 B1_99 0 5.038e-16
LB1_99 B1_99 B1_100 6.5385e-10
BB1_100 B1_100 0 JJR area=1
CB1_100 B1_100 0 5.038e-16
LB1_100 B1_100 B1_101 6.5385e-10
BB1_101 B1_101 0 JJR area=1
CB1_101 B1_101 0 5.038e-16
LB1_101 B1_101 B1_102 6.5385e-10
BB1_102 B1_102 0 JJR area=1
CB1_102 B1_102 0 5.038e-16
LB1_102 B1_102 B1_103 6.5385e-10
BB1_103 B1_103 0 JJR area=1
CB1_103 B1_103 0 5.038e-16
LB1_103 B1_103 B1_104 6.5385e-10
BB1_104 B1_104 0 JJR area=1
CB1_104 B1_104 0 5.038e-16
LB1_104 B1_104 B1_105 6.5385e-10
BB1_105 B1_105 0 JJR area=1
CB1_105 B1_105 0 5.038e-16
LB1_105 B1_105 B1_106 6.5385e-10
BB1_106 B1_106 0 JJR area=1
CB1_106 B1_106 0 5.038e-16
LB1_106 B1_106 B1_107 6.5385e-10
BB1_107 B1_107 0 JJR area=1
CB1_107 B1_107 0 5.038e-16
LB1_107 B1_107 B1_108 6.5385e-10
BB1_108 B1_108 0 JJR area=1
CB1_108 B1_108 0 5.038e-16
LB1_108 B1_108 B1_109 6.5385e-10
BB1_109 B1_109 0 JJR area=1
CB1_109 B1_109 0 5.038e-16
LB1_109 B1_109 B1_110 6.5385e-10
BB1_110 B1_110 0 JJR area=1
CB1_110 B1_110 0 5.038e-16
LB1_110 B1_110 B1_111 6.5384e-10
BB1_111 B1_111 SG_111 JJR area=1
CB1_111 B1_111 0 5.037e-16
LB1_111 B1_111 B1_112 6.5382e-10
BB1_112 B1_112 SG_112 JJR area=1
CB1_112 B1_112 0 5.031e-16
LB1_112 B1_112 B1_113 6.5377e-10
BB1_113 B1_113 SG_113 JJR area=1
CB1_113 B1_113 0 5.018e-16
LB1_113 B1_113 B1_114 6.5368e-10
BB1_114 B1_114 SG_114 JJR area=1
CB1_114 B1_114 0 4.998e-16
LB1_114 B1_114 B1_115 6.5356e-10
BB1_115 B1_115 SG_115 JJR area=1
CB1_115 B1_115 0 4.973e-16
LB1_115 B1_115 B1_116 6.534e-10
BB1_116 B1_116 SG_116 JJR area=1
CB1_116 B1_116 0 4.941e-16
LB1_116 B1_116 B1_117 6.5321e-10
BB1_117 B1_117 SG_117 JJR area=1
CB1_117 B1_117 0 4.903e-16
LB1_117 B1_117 B1_118 6.5299e-10
BB1_118 B1_118 SG_118 JJR area=1
CB1_118 B1_118 0 4.86e-16
LB1_118 B1_118 B1_119 6.5273e-10
BB1_119 B1_119 SG_119 JJR area=1
CB1_119 B1_119 0 4.811e-16
LB1_119 B1_119 B1_120 6.5245e-10
BB1_120 B1_120 SG_120 JJR area=1
CB1_120 B1_120 0 4.757e-16
LB1_120 B1_120 B1_121 6.5214e-10
BB1_121 B1_121 SG_121 JJR area=1
CB1_121 B1_121 0 4.698e-16
LB1_121 B1_121 B1_122 6.5181e-10
BB1_122 B1_122 SG_122 JJR area=1
CB1_122 B1_122 0 4.635e-16
LB1_122 B1_122 B1_123 6.5145e-10
BB1_123 B1_123 SG_123 JJR area=1
CB1_123 B1_123 0 4.567e-16
LB1_123 B1_123 B1_124 6.5107e-10
BB1_124 B1_124 SG_124 JJR area=1
CB1_124 B1_124 0 4.496e-16
LB1_124 B1_124 B1_125 6.5067e-10
BB1_125 B1_125 SG_125 JJR area=1
CB1_125 B1_125 0 4.422e-16
LB1_125 B1_125 B1_126 6.5026e-10
BB1_126 B1_126 SG_126 JJR area=1
CB1_126 B1_126 0 4.346e-16
LB1_126 B1_126 B1_127 6.4983e-10
BB1_127 B1_127 SG_127 JJR area=1
CB1_127 B1_127 0 4.267e-16
LB1_127 B1_127 B1_128 6.4939e-10
BB1_128 B1_128 SG_128 JJR area=1
CB1_128 B1_128 0 4.186e-16
LB1_128 B1_128 B1_129 6.4894e-10
BB1_129 B1_129 SG_129 JJR area=1
CB1_129 B1_129 0 4.104e-16
LB1_129 B1_129 B1_130 6.4849e-10
BB1_130 B1_130 SG_130 JJR area=1
CB1_130 B1_130 0 4.021e-16
LB1_130 B1_130 B1_131 6.4803e-10
BB1_131 B1_131 SG_131 JJR area=1
CB1_131 B1_131 0 3.938e-16
LB1_131 B1_131 B1_132 6.4758e-10
BB1_132 B1_132 SG_132 JJR area=1
CB1_132 B1_132 0 3.855e-16
LB1_132 B1_132 B1_133 6.4713e-10
BB1_133 B1_133 SG_133 JJR area=1
CB1_133 B1_133 0 3.772e-16
LB1_133 B1_133 B1_134 6.4668e-10
BB1_134 B1_134 SG_134 JJR area=1
CB1_134 B1_134 0 3.692e-16
LB1_134 B1_134 B1_135 6.4624e-10
BB1_135 B1_135 SG_135 JJR area=1
CB1_135 B1_135 0 3.613e-16
LB1_135 B1_135 B1_136 6.4581e-10
BB1_136 B1_136 SG_136 JJR area=1
CB1_136 B1_136 0 3.536e-16
LB1_136 B1_136 B1_137 6.454e-10
BB1_137 B1_137 SG_137 JJR area=1
CB1_137 B1_137 0 3.462e-16
LB1_137 B1_137 B1_138 6.45e-10
BB1_138 B1_138 SG_138 JJR area=1
CB1_138 B1_138 0 3.391e-16
LB1_138 B1_138 B1_139 6.4462e-10
BB1_139 B1_139 SG_139 JJR area=1
CB1_139 B1_139 0 3.324e-16
LB1_139 B1_139 B1_140 6.4426e-10
BB1_140 B1_140 SG_140 JJR area=1
CB1_140 B1_140 0 3.26e-16
LB1_140 B1_140 B1_141 6.4393e-10
BB1_141 B1_141 SG_141 JJR area=1
CB1_141 B1_141 0 3.201e-16
LB1_141 B1_141 B1_142 6.4362e-10
BB1_142 B1_142 SG_142 JJR area=1
CB1_142 B1_142 0 3.147e-16
LB1_142 B1_142 B1_143 6.4334e-10
BB1_143 B1_143 SG_143 JJR area=1
CB1_143 B1_143 0 3.099e-16
LB1_143 B1_143 B1_144 6.4308e-10
BB1_144 B1_144 SG_144 JJR area=1
CB1_144 B1_144 0 3.055e-16
LB1_144 B1_144 B1_145 6.4286e-10
BB1_145 B1_145 SG_145 JJR area=1
CB1_145 B1_145 0 3.017e-16
LB1_145 B1_145 B1_146 6.4267e-10
BB1_146 B1_146 SG_146 JJR area=1
CB1_146 B1_146 0 2.986e-16
LB1_146 B1_146 B1_147 6.4251e-10
BB1_147 B1_147 SG_147 JJR area=1
CB1_147 B1_147 0 2.96e-16
LB1_147 B1_147 B1_148 6.4239e-10
BB1_148 B1_148 SG_148 JJR area=1
CB1_148 B1_148 0 2.941e-16
LB1_148 B1_148 B1_149 6.423e-10
BB1_149 B1_149 SG_149 JJR area=1
CB1_149 B1_149 0 2.928e-16
LB1_149 B1_149 B1_150 6.4224e-10
BB1_150 B1_150 SG_150 JJR area=1
CB1_150 B1_150 0 2.921e-16
LB1_150 B1_150 B1_151 6.4222e-10
BB1_151 B1_151 SG_151 JJR area=1
CB1_151 B1_151 0 2.92e-16
LB1_151 B1_151 B1_152 6.4222e-10
BB1_152 B1_152 SG_152 JJR area=1
CB1_152 B1_152 0 2.92e-16
LB1_152 B1_152 B1_153 6.4222e-10
BB1_153 B1_153 SG_153 JJR area=1
CB1_153 B1_153 0 2.92e-16
LB1_153 B1_153 B1_154 6.4222e-10
BB1_154 B1_154 SG_154 JJR area=1
CB1_154 B1_154 0 2.92e-16
LB1_154 B1_154 B1_155 6.4222e-10
BB1_155 B1_155 SG_155 JJR area=1
CB1_155 B1_155 0 2.92e-16
LB1_155 B1_155 B1_156 6.4222e-10
BB1_156 B1_156 SG_156 JJR area=1
CB1_156 B1_156 0 2.92e-16
LB1_156 B1_156 B1_157 6.4222e-10
BB1_157 B1_157 SG_157 JJR area=1
CB1_157 B1_157 0 2.92e-16
LB1_157 B1_157 B1_158 6.4222e-10
BB1_158 B1_158 SG_158 JJR area=1
CB1_158 B1_158 0 2.92e-16
LB1_158 B1_158 B1_159 6.4222e-10
BB1_159 B1_159 SG_159 JJR area=1
CB1_159 B1_159 0 2.92e-16
LB1_159 B1_159 B1_160 6.4222e-10
BB1_160 B1_160 SG_160 JJR area=1
CB1_160 B1_160 0 2.92e-16
LB1_160 B1_160 B1_161 6.4222e-10
BB1_161 B1_161 SG_161 JJR area=1
CB1_161 B1_161 0 2.92e-16
LB1_161 B1_161 B1_162 6.4222e-10
BB1_162 B1_162 SG_162 JJR area=1
CB1_162 B1_162 0 2.92e-16
LB1_162 B1_162 B1_163 6.4222e-10
BB1_163 B1_163 SG_163 JJR area=1
CB1_163 B1_163 0 2.92e-16
LB1_163 B1_163 B1_164 6.4222e-10
BB1_164 B1_164 SG_164 JJR area=1
CB1_164 B1_164 0 2.92e-16
LB1_164 B1_164 B1_165 6.4222e-10
BB1_165 B1_165 SG_165 JJR area=1
CB1_165 B1_165 0 2.92e-16
LB1_165 B1_165 B1_166 6.4222e-10
BB1_166 B1_166 SG_166 JJR area=1
CB1_166 B1_166 0 2.92e-16
LB1_166 B1_166 B1_167 6.4222e-10
BB1_167 B1_167 SG_167 JJR area=1
CB1_167 B1_167 0 2.92e-16
LB1_167 B1_167 B1_168 6.4222e-10
BB1_168 B1_168 SG_168 JJR area=1
CB1_168 B1_168 0 2.92e-16
LB1_168 B1_168 B1_169 6.4222e-10
BB1_169 B1_169 SG_169 JJR area=1
CB1_169 B1_169 0 2.92e-16
LB1_169 B1_169 B1_170 6.4222e-10
BB1_170 B1_170 SG_170 JJR area=1
CB1_170 B1_170 0 2.92e-16
LB1_170 B1_170 B1_171 6.4222e-10
BB1_171 B1_171 SG_171 JJR area=1
CB1_171 B1_171 0 2.92e-16
LB1_171 B1_171 B1_172 6.4222e-10
BB1_172 B1_172 SG_172 JJR area=1
CB1_172 B1_172 0 2.92e-16
LB1_172 B1_172 B1_173 6.4222e-10
BB1_173 B1_173 SG_173 JJR area=1
CB1_173 B1_173 0 2.92e-16
LB1_173 B1_173 B1_174 6.4222e-10
BB1_174 B1_174 SG_174 JJR area=1
CB1_174 B1_174 0 2.92e-16
LB1_174 B1_174 B1_175 6.4222e-10
BB1_175 B1_175 SG_175 JJR area=1
CB1_175 B1_175 0 2.92e-16
LB1_175 B1_175 B1_176 6.4222e-10
BB1_176 B1_176 SG_176 JJR area=1
CB1_176 B1_176 0 2.92e-16
LB1_176 B1_176 B1_177 6.4222e-10
BB1_177 B1_177 SG_177 JJR area=1
CB1_177 B1_177 0 2.92e-16
LB1_177 B1_177 B1_178 6.4222e-10
BB1_178 B1_178 SG_178 JJR area=1
CB1_178 B1_178 0 2.92e-16
LB1_178 B1_178 B1_179 6.4222e-10
BB1_179 B1_179 SG_179 JJR area=1
CB1_179 B1_179 0 2.92e-16
LB1_179 B1_179 B1_180 6.4222e-10
BB1_180 B1_180 SG_180 JJR area=1
CB1_180 B1_180 0 2.92e-16
LB1_180 B1_180 B1_181 6.4222e-10
BB1_181 B1_181 SG_181 JJR area=1
CB1_181 B1_181 0 2.92e-16
LB1_181 B1_181 B1_182 6.4222e-10
BB1_182 B1_182 SG_182 JJR area=1
CB1_182 B1_182 0 2.92e-16
LB1_182 B1_182 B1_183 6.4222e-10
BB1_183 B1_183 SG_183 JJR area=1
CB1_183 B1_183 0 2.92e-16
LB1_183 B1_183 B1_184 6.4222e-10
BB1_184 B1_184 SG_184 JJR area=1
CB1_184 B1_184 0 2.92e-16
LB1_184 B1_184 B1_185 6.4222e-10
BB1_185 B1_185 SG_185 JJR area=1
CB1_185 B1_185 0 2.92e-16
LB1_185 B1_185 B1_186 6.4222e-10
BB1_186 B1_186 SG_186 JJR area=1
CB1_186 B1_186 0 2.92e-16
LB1_186 B1_186 B1_187 6.4222e-10
BB1_187 B1_187 SG_187 JJR area=1
CB1_187 B1_187 0 2.92e-16
LB1_187 B1_187 B1_188 6.4222e-10
BB1_188 B1_188 SG_188 JJR area=1
CB1_188 B1_188 0 2.92e-16
LB1_188 B1_188 B1_189 6.4222e-10
BB1_189 B1_189 SG_189 JJR area=1
CB1_189 B1_189 0 2.92e-16
LB1_189 B1_189 B1_190 6.4222e-10
BB1_190 B1_190 SG_190 JJR area=1
CB1_190 B1_190 0 2.92e-16
LB1_190 B1_190 B1_191 6.4222e-10
BB1_191 B1_191 SG_191 JJR area=1
CB1_191 B1_191 0 2.92e-16
LB1_191 B1_191 B1_192 6.4222e-10
BB1_192 B1_192 SG_192 JJR area=1
CB1_192 B1_192 0 2.92e-16
LB1_192 B1_192 B1_193 6.4222e-10
BB1_193 B1_193 SG_193 JJR area=1
CB1_193 B1_193 0 2.92e-16
LB1_193 B1_193 B1_194 6.4222e-10
BB1_194 B1_194 SG_194 JJR area=1
CB1_194 B1_194 0 2.92e-16
LB1_194 B1_194 B1_195 6.4222e-10
BB1_195 B1_195 SG_195 JJR area=1
CB1_195 B1_195 0 2.92e-16
LB1_195 B1_195 B1_196 6.4222e-10
BB1_196 B1_196 SG_196 JJR area=1
CB1_196 B1_196 0 2.92e-16
LB1_196 B1_196 B1_197 6.4222e-10
BB1_197 B1_197 SG_197 JJR area=1
CB1_197 B1_197 0 2.92e-16
LB1_197 B1_197 B1_198 6.4222e-10
BB1_198 B1_198 SG_198 JJR area=1
CB1_198 B1_198 0 2.92e-16
LB1_198 B1_198 B1_199 6.4222e-10
BB1_199 B1_199 SG_199 JJR area=1
CB1_199 B1_199 0 2.92e-16
LB1_199 B1_199 B1_200 6.4222e-10
BB1_200 B1_200 SG_200 JJR area=1
CB1_200 B1_200 0 2.92e-16
LB1_200 B1_200 B1_201 6.4222e-10
BB1_201 B1_201 SG_201 JJR area=1
CB1_201 B1_201 0 2.92e-16
LB1_201 B1_201 B1_202 6.4222e-10
BB1_202 B1_202 SG_202 JJR area=1
CB1_202 B1_202 0 2.92e-16
LB1_202 B1_202 B1_203 6.4222e-10
BB1_203 B1_203 SG_203 JJR area=1
CB1_203 B1_203 0 2.92e-16
LB1_203 B1_203 B1_204 6.4222e-10
BB1_204 B1_204 SG_204 JJR area=1
CB1_204 B1_204 0 2.92e-16
LB1_204 B1_204 B1_205 6.4222e-10
BB1_205 B1_205 SG_205 JJR area=1
CB1_205 B1_205 0 2.92e-16
LB1_205 B1_205 B1_206 6.4222e-10
BB1_206 B1_206 SG_206 JJR area=1
CB1_206 B1_206 0 2.92e-16
LB1_206 B1_206 B1_207 6.4222e-10
BB1_207 B1_207 SG_207 JJR area=1
CB1_207 B1_207 0 2.92e-16
LB1_207 B1_207 B1_208 6.4222e-10
BB1_208 B1_208 SG_208 JJR area=1
CB1_208 B1_208 0 2.92e-16
LB1_208 B1_208 B1_209 6.4222e-10
BB1_209 B1_209 SG_209 JJR area=1
CB1_209 B1_209 0 2.92e-16
LB1_209 B1_209 B1_210 6.4222e-10
BB1_210 B1_210 SG_210 JJR area=1
CB1_210 B1_210 0 2.92e-16
LB1_210 B1_210 B1_211 6.4222e-10
BB1_211 B1_211 SG_211 JJR area=1
CB1_211 B1_211 0 2.92e-16
LB1_211 B1_211 B1_212 6.4222e-10
BB1_212 B1_212 SG_212 JJR area=1
CB1_212 B1_212 0 2.92e-16
LB1_212 B1_212 B1_213 6.4222e-10
BB1_213 B1_213 SG_213 JJR area=1
CB1_213 B1_213 0 2.92e-16
LB1_213 B1_213 B1_214 6.4222e-10
BB1_214 B1_214 SG_214 JJR area=1
CB1_214 B1_214 0 2.92e-16
LB1_214 B1_214 B1_215 6.4222e-10
BB1_215 B1_215 SG_215 JJR area=1
CB1_215 B1_215 0 2.92e-16
LB1_215 B1_215 B1_216 6.4222e-10
BB1_216 B1_216 SG_216 JJR area=1
CB1_216 B1_216 0 2.92e-16
LB1_216 B1_216 B1_217 6.4222e-10
BB1_217 B1_217 SG_217 JJR area=1
CB1_217 B1_217 0 2.92e-16
LB1_217 B1_217 B1_218 6.4222e-10
BB1_218 B1_218 SG_218 JJR area=1
CB1_218 B1_218 0 2.92e-16
LB1_218 B1_218 B1_219 6.4222e-10
BB1_219 B1_219 SG_219 JJR area=1
CB1_219 B1_219 0 2.92e-16
LB1_219 B1_219 B1_220 6.4222e-10
BB1_220 B1_220 SG_220 JJR area=1
CB1_220 B1_220 0 2.92e-16
LB1_220 B1_220 B1_221 6.4222e-10
BB1_221 B1_221 SG_221 JJR area=1
CB1_221 B1_221 0 2.92e-16
LB1_221 B1_221 B1_222 6.4222e-10
BB1_222 B1_222 SG_222 JJR area=1
CB1_222 B1_222 0 2.92e-16
LB1_222 B1_222 B1_223 6.4222e-10
BB1_223 B1_223 SG_223 JJR area=1
CB1_223 B1_223 0 2.92e-16
LB1_223 B1_223 B1_224 6.4222e-10
BB1_224 B1_224 SG_224 JJR area=1
CB1_224 B1_224 0 2.92e-16
LB1_224 B1_224 B1_225 6.4222e-10
BB1_225 B1_225 SG_225 JJR area=1
CB1_225 B1_225 0 2.92e-16
LB1_225 B1_225 B1_226 6.4222e-10
BB1_226 B1_226 SG_226 JJR area=1
CB1_226 B1_226 0 2.92e-16
LB1_226 B1_226 B1_227 6.4222e-10
BB1_227 B1_227 SG_227 JJR area=1
CB1_227 B1_227 0 2.92e-16
LB1_227 B1_227 B1_228 6.4222e-10
BB1_228 B1_228 SG_228 JJR area=1
CB1_228 B1_228 0 2.92e-16
LB1_228 B1_228 B1_229 6.4222e-10
BB1_229 B1_229 SG_229 JJR area=1
CB1_229 B1_229 0 2.92e-16
LB1_229 B1_229 B1_230 6.4222e-10
BB1_230 B1_230 SG_230 JJR area=1
CB1_230 B1_230 0 2.92e-16
LB1_230 B1_230 B1_231 6.4222e-10
BB1_231 B1_231 SG_231 JJR area=1
CB1_231 B1_231 0 2.92e-16
LB1_231 B1_231 B1_232 6.4222e-10
BB1_232 B1_232 SG_232 JJR area=1
CB1_232 B1_232 0 2.92e-16
LB1_232 B1_232 B1_233 6.4222e-10
BB1_233 B1_233 SG_233 JJR area=1
CB1_233 B1_233 0 2.92e-16
LB1_233 B1_233 B1_234 6.4222e-10
BB1_234 B1_234 SG_234 JJR area=1
CB1_234 B1_234 0 2.92e-16
LB1_234 B1_234 B1_235 6.4222e-10
BB1_235 B1_235 SG_235 JJR area=1
CB1_235 B1_235 0 2.92e-16
LB1_235 B1_235 B1_236 6.4222e-10
BB1_236 B1_236 SG_236 JJR area=1
CB1_236 B1_236 0 2.92e-16
LB1_236 B1_236 B1_237 6.4222e-10
BB1_237 B1_237 SG_237 JJR area=1
CB1_237 B1_237 0 2.92e-16
LB1_237 B1_237 B1_238 6.4222e-10
BB1_238 B1_238 SG_238 JJR area=1
CB1_238 B1_238 0 2.92e-16
LB1_238 B1_238 B1_239 6.4222e-10
BB1_239 B1_239 SG_239 JJR area=1
CB1_239 B1_239 0 2.92e-16
LB1_239 B1_239 B1_240 6.4222e-10
BB1_240 B1_240 SG_240 JJR area=1
CB1_240 B1_240 0 2.92e-16
LB1_240 B1_240 B1_241 6.4222e-10
BB1_241 B1_241 SG_241 JJR area=1
CB1_241 B1_241 0 2.92e-16
LB1_241 B1_241 B1_242 6.4222e-10
BB1_242 B1_242 SG_242 JJR area=1
CB1_242 B1_242 0 2.92e-16
LB1_242 B1_242 B1_243 6.4222e-10
BB1_243 B1_243 SG_243 JJR area=1
CB1_243 B1_243 0 2.92e-16
LB1_243 B1_243 B1_244 6.4222e-10
BB1_244 B1_244 SG_244 JJR area=1
CB1_244 B1_244 0 2.92e-16
LB1_244 B1_244 B1_245 6.4222e-10
BB1_245 B1_245 SG_245 JJR area=1
CB1_245 B1_245 0 2.92e-16
LB1_245 B1_245 B1_246 6.4222e-10
BB1_246 B1_246 SG_246 JJR area=1
CB1_246 B1_246 0 2.92e-16
LB1_246 B1_246 B1_247 6.4222e-10
BB1_247 B1_247 SG_247 JJR area=1
CB1_247 B1_247 0 2.92e-16
LB1_247 B1_247 B1_248 6.4222e-10
BB1_248 B1_248 SG_248 JJR area=1
CB1_248 B1_248 0 2.92e-16
LB1_248 B1_248 B1_249 6.4222e-10
BB1_249 B1_249 SG_249 JJR area=1
CB1_249 B1_249 0 2.92e-16
LB1_249 B1_249 B1_250 6.4222e-10
BB1_250 B1_250 SG_250 JJR area=1
CB1_250 B1_250 0 2.92e-16
LB1_250 B1_250 B1_251 6.4222e-10
BB1_251 B1_251 SG_251 JJR area=1
CB1_251 B1_251 0 2.921e-16
LB1_251 B1_251 B1_252 6.4224e-10
BB1_252 B1_252 SG_252 JJR area=1
CB1_252 B1_252 0 2.928e-16
LB1_252 B1_252 B1_253 6.423e-10
BB1_253 B1_253 SG_253 JJR area=1
CB1_253 B1_253 0 2.941e-16
LB1_253 B1_253 B1_254 6.4239e-10
BB1_254 B1_254 SG_254 JJR area=1
CB1_254 B1_254 0 2.96e-16
LB1_254 B1_254 B1_255 6.4251e-10
BB1_255 B1_255 SG_255 JJR area=1
CB1_255 B1_255 0 2.986e-16
LB1_255 B1_255 B1_256 6.4267e-10
BB1_256 B1_256 SG_256 JJR area=1
CB1_256 B1_256 0 3.017e-16
LB1_256 B1_256 B1_257 6.4286e-10
BB1_257 B1_257 SG_257 JJR area=1
CB1_257 B1_257 0 3.055e-16
LB1_257 B1_257 B1_258 6.4308e-10
BB1_258 B1_258 SG_258 JJR area=1
CB1_258 B1_258 0 3.099e-16
LB1_258 B1_258 B1_259 6.4334e-10
BB1_259 B1_259 SG_259 JJR area=1
CB1_259 B1_259 0 3.147e-16
LB1_259 B1_259 B1_260 6.4362e-10
BB1_260 B1_260 SG_260 JJR area=1
CB1_260 B1_260 0 3.201e-16
LB1_260 B1_260 B1_261 6.4393e-10
BB1_261 B1_261 SG_261 JJR area=1
CB1_261 B1_261 0 3.26e-16
LB1_261 B1_261 B1_262 6.4426e-10
BB1_262 B1_262 SG_262 JJR area=1
CB1_262 B1_262 0 3.324e-16
LB1_262 B1_262 B1_263 6.4462e-10
BB1_263 B1_263 SG_263 JJR area=1
CB1_263 B1_263 0 3.391e-16
LB1_263 B1_263 B1_264 6.45e-10
BB1_264 B1_264 SG_264 JJR area=1
CB1_264 B1_264 0 3.462e-16
LB1_264 B1_264 B1_265 6.454e-10
BB1_265 B1_265 SG_265 JJR area=1
CB1_265 B1_265 0 3.536e-16
LB1_265 B1_265 B1_266 6.4581e-10
BB1_266 B1_266 SG_266 JJR area=1
CB1_266 B1_266 0 3.613e-16
LB1_266 B1_266 B1_267 6.4624e-10
BB1_267 B1_267 SG_267 JJR area=1
CB1_267 B1_267 0 3.692e-16
LB1_267 B1_267 B1_268 6.4668e-10
BB1_268 B1_268 SG_268 JJR area=1
CB1_268 B1_268 0 3.772e-16
LB1_268 B1_268 B1_269 6.4713e-10
BB1_269 B1_269 SG_269 JJR area=1
CB1_269 B1_269 0 3.855e-16
LB1_269 B1_269 B1_270 6.4758e-10
BB1_270 B1_270 SG_270 JJR area=1
CB1_270 B1_270 0 3.938e-16
LB1_270 B1_270 B1_271 6.4803e-10
BB1_271 B1_271 SG_271 JJR area=1
CB1_271 B1_271 0 4.021e-16
LB1_271 B1_271 B1_272 6.4849e-10
BB1_272 B1_272 SG_272 JJR area=1
CB1_272 B1_272 0 4.104e-16
LB1_272 B1_272 B1_273 6.4894e-10
BB1_273 B1_273 SG_273 JJR area=1
CB1_273 B1_273 0 4.186e-16
LB1_273 B1_273 B1_274 6.4939e-10
BB1_274 B1_274 SG_274 JJR area=1
CB1_274 B1_274 0 4.267e-16
LB1_274 B1_274 B1_275 6.4983e-10
BB1_275 B1_275 SG_275 JJR area=1
CB1_275 B1_275 0 4.346e-16
LB1_275 B1_275 B1_276 6.5026e-10
BB1_276 B1_276 SG_276 JJR area=1
CB1_276 B1_276 0 4.422e-16
LB1_276 B1_276 B1_277 6.5067e-10
BB1_277 B1_277 SG_277 JJR area=1
CB1_277 B1_277 0 4.496e-16
LB1_277 B1_277 B1_278 6.5107e-10
BB1_278 B1_278 SG_278 JJR area=1
CB1_278 B1_278 0 4.567e-16
LB1_278 B1_278 B1_279 6.5145e-10
BB1_279 B1_279 SG_279 JJR area=1
CB1_279 B1_279 0 4.635e-16
LB1_279 B1_279 B1_280 6.5181e-10
BB1_280 B1_280 SG_280 JJR area=1
CB1_280 B1_280 0 4.698e-16
LB1_280 B1_280 B1_281 6.5214e-10
BB1_281 B1_281 SG_281 JJR area=1
CB1_281 B1_281 0 4.757e-16
LB1_281 B1_281 B1_282 6.5245e-10
BB1_282 B1_282 SG_282 JJR area=1
CB1_282 B1_282 0 4.811e-16
LB1_282 B1_282 B1_283 6.5273e-10
BB1_283 B1_283 SG_283 JJR area=1
CB1_283 B1_283 0 4.86e-16
LB1_283 B1_283 B1_284 6.5299e-10
BB1_284 B1_284 SG_284 JJR area=1
CB1_284 B1_284 0 4.903e-16
LB1_284 B1_284 B1_285 6.5321e-10
BB1_285 B1_285 SG_285 JJR area=1
CB1_285 B1_285 0 4.941e-16
LB1_285 B1_285 B1_286 6.534e-10
BB1_286 B1_286 SG_286 JJR area=1
CB1_286 B1_286 0 4.973e-16
LB1_286 B1_286 B1_287 6.5356e-10
BB1_287 B1_287 SG_287 JJR area=1
CB1_287 B1_287 0 4.998e-16
LB1_287 B1_287 B1_288 6.5368e-10
BB1_288 B1_288 SG_288 JJR area=1
CB1_288 B1_288 0 5.018e-16
LB1_288 B1_288 B1_289 6.5377e-10
BB1_289 B1_289 SG_289 JJR area=1
CB1_289 B1_289 0 5.031e-16
LB1_289 B1_289 B1_290 6.5382e-10
BB1_290 B1_290 SG_290 JJR area=1
CB1_290 B1_290 0 5.037e-16
LB1_290 B1_290 B1_291 6.5384e-10
BB1_291 B1_291 MB_291 JJR area=1
CB1_291 B1_291 0 5.038e-16
LB1_291 B1_291 B1_292 6.5385e-10
BB1_292 B1_292 MB_292 JJR area=1
CB1_292 B1_292 0 5.038e-16
LB1_292 B1_292 B1_293 6.5385e-10
BB1_293 B1_293 MB_293 JJR area=1
CB1_293 B1_293 0 5.038e-16
LB1_293 B1_293 B1_294 6.5385e-10
BB1_294 B1_294 MB_294 JJR area=1
CB1_294 B1_294 0 5.038e-16
LB1_294 B1_294 B1_295 6.5385e-10
BB1_295 B1_295 MB_295 JJR area=1
CB1_295 B1_295 0 5.038e-16
LB1_295 B1_295 B1_296 6.5385e-10
BB1_296 B1_296 MB_296 JJR area=1
CB1_296 B1_296 0 5.038e-16
LB1_296 B1_296 B1_297 6.5385e-10
BB1_297 B1_297 MB_297 JJR area=1
CB1_297 B1_297 0 5.038e-16
LB1_297 B1_297 B1_298 6.5385e-10
BB1_298 B1_298 MB_298 JJR area=1
CB1_298 B1_298 0 5.038e-16
LB1_298 B1_298 B1_299 6.5385e-10
BB1_299 B1_299 MB_299 JJR area=1
CB1_299 B1_299 0 5.038e-16
LB1_299 B1_299 B1_300 6.5385e-10
BB1_300 B1_300 MB_300 JJR area=1
CB1_300 B1_300 0 5.038e-16
LB1_300 B1_300 B1_301 6.5385e-10
BB1_301 B1_301 MB_301 JJR area=1
CB1_301 B1_301 0 5.038e-16
LB1_301 B1_301 B1_302 6.5385e-10
BB1_302 B1_302 MB_302 JJR area=1
CB1_302 B1_302 0 5.038e-16
LB1_302 B1_302 B1_303 6.5385e-10
BB1_303 B1_303 MB_303 JJR area=1
CB1_303 B1_303 0 5.038e-16
LB1_303 B1_303 B1_304 6.5385e-10
BB1_304 B1_304 MB_304 JJR area=1
CB1_304 B1_304 0 5.038e-16
LB1_304 B1_304 B1_305 6.5385e-10
BB1_305 B1_305 MB_305 JJR area=1
CB1_305 B1_305 0 5.038e-16
LB1_305 B1_305 B1_306 6.5385e-10
BB1_306 B1_306 MB_306 JJR area=1
CB1_306 B1_306 0 5.038e-16
LB1_306 B1_306 B1_307 6.5385e-10
BB1_307 B1_307 MB_307 JJR area=1
CB1_307 B1_307 0 5.038e-16
LB1_307 B1_307 B1_308 6.5385e-10
BB1_308 B1_308 MB_308 JJR area=1
CB1_308 B1_308 0 5.038e-16
LB1_308 B1_308 B1_309 6.5385e-10
BB1_309 B1_309 MB_309 JJR area=1
CB1_309 B1_309 0 5.038e-16
LB1_309 B1_309 B1_310 6.5385e-10
BB1_310 B1_310 MB_310 JJR area=1
CB1_310 B1_310 0 5.038e-16
LB1_310 B1_310 B1_311 6.5385e-10
BB1_311 B1_311 MB_311 JJR area=1
CB1_311 B1_311 0 5.038e-16
LB1_311 B1_311 B1_312 6.5385e-10
BB1_312 B1_312 0 JJR area=1
CB1_312 B1_312 0 5.038e-16
LB1_312 B1_312 B1_313 6.5385e-10
BB1_313 B1_313 0 JJR area=1
CB1_313 B1_313 0 5.038e-16
LB1_313 B1_313 B1_314 6.5385e-10
BB1_314 B1_314 0 JJR area=1
CB1_314 B1_314 0 5.038e-16
LB1_314 B1_314 B1_315 6.5385e-10
BB1_315 B1_315 0 JJR area=1
CB1_315 B1_315 0 5.038e-16
LB1_315 B1_315 B1_316 6.5385e-10
BB1_316 B1_316 0 JJR area=1
CB1_316 B1_316 0 5.038e-16
LB1_316 B1_316 B1_317 6.5385e-10
BB1_317 B1_317 0 JJR area=1
CB1_317 B1_317 0 5.038e-16
LB1_317 B1_317 B1_318 6.5385e-10
BB1_318 B1_318 0 JJR area=1
CB1_318 B1_318 0 5.038e-16
LB1_318 B1_318 B1_319 6.5385e-10
BB1_319 B1_319 0 JJR area=1
CB1_319 B1_319 0 5.038e-16
LB1_319 B1_319 B1_320 6.5385e-10
BB1_320 B1_320 0 JJR area=1
CB1_320 B1_320 0 5.038e-16
LB1_320 B1_320 B1_321 6.5385e-10
BB1_321 B1_321 0 JJR area=1
CB1_321 B1_321 0 5.038e-16
LB1_321 B1_321 B1_322 6.5385e-10
BB1_322 B1_322 0 JJR area=1
CB1_322 B1_322 0 5.038e-16
LB1_322 B1_322 B1_323 6.5385e-10
BB1_323 B1_323 0 JJR area=1
CB1_323 B1_323 0 5.038e-16
LB1_323 B1_323 B1_324 6.5385e-10
BB1_324 B1_324 0 JJR area=1
CB1_324 B1_324 0 5.038e-16
LB1_324 B1_324 B1_325 6.5385e-10
BB1_325 B1_325 0 JJR area=1
CB1_325 B1_325 0 5.038e-16
LB1_325 B1_325 B1_326 6.5385e-10
BB1_326 B1_326 0 JJR area=1
CB1_326 B1_326 0 5.038e-16
LB1_326 B1_326 B1_327 6.5385e-10
BB1_327 B1_327 0 JJR area=1
CB1_327 B1_327 0 5.038e-16
LB1_327 B1_327 B1_328 6.5385e-10
BB1_328 B1_328 0 JJR area=1
CB1_328 B1_328 0 5.038e-16
LB1_328 B1_328 B1_329 6.5385e-10
BB1_329 B1_329 0 JJR area=1
CB1_329 B1_329 0 5.038e-16
LB1_329 B1_329 B1_330 6.5385e-10
BB1_330 B1_330 0 JJR area=1
CB1_330 B1_330 0 5.038e-16
LB1_330 B1_330 B1_331 6.5385e-10
BB1_331 B1_331 0 JJR area=1
CB1_331 B1_331 0 5.038e-16
LB1_331 B1_331 B1_332 6.5385e-10
BB1_332 B1_332 0 JJR area=1
CB1_332 B1_332 0 5.038e-16
LB1_332 B1_332 B1_333 6.5385e-10
BB1_333 B1_333 0 JJR area=1
CB1_333 B1_333 0 5.038e-16
LB1_333 B1_333 B1_334 6.5385e-10
BB1_334 B1_334 0 JJR area=1
CB1_334 B1_334 0 5.038e-16
LB1_334 B1_334 B1_335 6.5385e-10
BB1_335 B1_335 0 JJR area=1
CB1_335 B1_335 0 5.038e-16
LB1_335 B1_335 B1_336 6.5385e-10
BB1_336 B1_336 0 JJR area=1
CB1_336 B1_336 0 5.038e-16
LB1_336 B1_336 B1_337 6.5385e-10
BB1_337 B1_337 0 JJR area=1
CB1_337 B1_337 0 5.038e-16
LB1_337 B1_337 B1_338 6.5385e-10
BB1_338 B1_338 0 JJR area=1
CB1_338 B1_338 0 5.038e-16
LB1_338 B1_338 B1_339 6.5385e-10
BB1_339 B1_339 0 JJR area=1
CB1_339 B1_339 0 5.038e-16
LB1_339 B1_339 B1_340 6.5385e-10
BB1_340 B1_340 0 JJR area=1
CB1_340 B1_340 0 5.038e-16
LB1_340 B1_340 B1_341 6.5385e-10
BB1_341 B1_341 0 JJR area=1
CB1_341 B1_341 0 5.038e-16
LB1_341 B1_341 B1_342 6.5385e-10
BB1_342 B1_342 0 JJR area=1
CB1_342 B1_342 0 5.038e-16
LB1_342 B1_342 B1_343 6.5385e-10
BB1_343 B1_343 0 JJR area=1
CB1_343 B1_343 0 5.038e-16
LB1_343 B1_343 B1_344 6.5385e-10
BB1_344 B1_344 0 JJR area=1
CB1_344 B1_344 0 5.038e-16
LB1_344 B1_344 B1_345 6.5385e-10
BB1_345 B1_345 0 JJR area=1
CB1_345 B1_345 0 5.038e-16
LB1_345 B1_345 B1_346 6.5385e-10
BB1_346 B1_346 0 JJR area=1
CB1_346 B1_346 0 5.038e-16
LB1_346 B1_346 B1_347 6.5385e-10
BB1_347 B1_347 0 JJR area=1
CB1_347 B1_347 0 5.038e-16
LB1_347 B1_347 B1_348 6.5385e-10
BB1_348 B1_348 0 JJR area=1
CB1_348 B1_348 0 5.038e-16
LB1_348 B1_348 B1_349 6.5385e-10
BB1_349 B1_349 0 JJR area=1
CB1_349 B1_349 0 5.038e-16
LB1_349 B1_349 B1_350 6.5385e-10
BB1_350 B1_350 0 JJR area=1
CB1_350 B1_350 0 5.038e-16
LB1_350 B1_350 B1_351 6.5385e-10
BB1_351 B1_351 0 JJR area=1
CB1_351 B1_351 0 5.038e-16
LB1_351 B1_351 B1_352 6.5385e-10
BB1_352 B1_352 0 JJR area=1
CB1_352 B1_352 0 5.038e-16
LB1_352 B1_352 B1_353 6.5385e-10
BB1_353 B1_353 0 JJR area=1
CB1_353 B1_353 0 5.038e-16
LB1_353 B1_353 B1_354 6.5385e-10
BB1_354 B1_354 0 JJR area=1
CB1_354 B1_354 0 5.038e-16
LB1_354 B1_354 B1_355 6.5385e-10
BB1_355 B1_355 0 JJR area=1
CB1_355 B1_355 0 5.038e-16
LB1_355 B1_355 B1_356 6.5385e-10
BB1_356 B1_356 0 JJR area=1
CB1_356 B1_356 0 5.038e-16
LB1_356 B1_356 B1_357 6.5385e-10
BB1_357 B1_357 0 JJR area=1
CB1_357 B1_357 0 5.038e-16
LB1_357 B1_357 B1_358 6.5385e-10
BB1_358 B1_358 0 JJR area=1
CB1_358 B1_358 0 5.038e-16
LB1_358 B1_358 B1_359 6.5385e-10
BB1_359 B1_359 0 JJR area=1
CB1_359 B1_359 0 5.038e-16
LB1_359 B1_359 B1_360 6.5385e-10
BB1_360 B1_360 0 JJR area=1
CB1_360 B1_360 0 5.038e-16
LB1_360 B1_360 B1_361 6.5385e-10
BB1_361 B1_361 0 JJR area=1
CB1_361 B1_361 0 5.038e-16
BINJ_B1 B1_361 0 JJI area=1
IINJ_B1 0 B1_361 pwl(0 0 20p 0 30p 1.933e-07 50p 0)
LCATCH_B1 B1_0 0 20n
IACC_B1_10 0 B1_351 pwl(0 0 50p 0 60p 4.027e-09 200p 4.027e-09 210p 0)
IACC_B1_11 0 B1_350 pwl(0 0 50p 0 60p 4.027e-09 200p 4.027e-09 210p 0)
IACC_B1_12 0 B1_349 pwl(0 0 50p 0 60p 4.027e-09 200p 4.027e-09 210p 0)
IACC_B1_13 0 B1_348 pwl(0 0 50p 0 60p 4.027e-09 200p 4.027e-09 210p 0)
IACC_B1_14 0 B1_347 pwl(0 0 50p 0 60p 4.027e-09 200p 4.027e-09 210p 0)
IACC_B1_15 0 B1_346 pwl(0 0 50p 0 60p 4.027e-09 200p 4.027e-09 210p 0)
IACC_B1_16 0 B1_345 pwl(0 0 50p 0 60p 4.027e-09 200p 4.027e-09 210p 0)
IACC_B1_17 0 B1_344 pwl(0 0 50p 0 60p 4.027e-09 200p 4.027e-09 210p 0)
IACC_B1_18 0 B1_343 pwl(0 0 50p 0 60p 4.027e-09 200p 4.027e-09 210p 0)
IACC_B1_19 0 B1_342 pwl(0 0 50p 0 60p 4.027e-09 200p 4.027e-09 210p 0)
IACC_B1_20 0 B1_341 pwl(0 0 50p 0 60p 4.027e-09 200p 4.027e-09 210p 0)
IACC_B1_21 0 B1_340 pwl(0 0 50p 0 60p 4.027e-09 200p 4.027e-09 210p 0)
IACC_B1_22 0 B1_339 pwl(0 0 50p 0 60p 4.027e-09 200p 4.027e-09 210p 0)
IACC_B1_23 0 B1_338 pwl(0 0 50p 0 60p 4.027e-09 200p 4.027e-09 210p 0)
IACC_B1_24 0 B1_337 pwl(0 0 50p 0 60p 4.027e-09 200p 4.027e-09 210p 0)
IACC_B1_25 0 B1_336 pwl(0 0 50p 0 60p 4.027e-09 200p 4.027e-09 210p 0)
IACC_B1_26 0 B1_335 pwl(0 0 50p 0 60p 4.027e-09 200p 4.027e-09 210p 0)
IACC_B1_27 0 B1_334 pwl(0 0 50p 0 60p 4.027e-09 200p 4.027e-09 210p 0)
IACC_B1_28 0 B1_333 pwl(0 0 50p 0 60p 4.027e-09 200p 4.027e-09 210p 0)
IACC_B1_29 0 B1_332 pwl(0 0 50p 0 60p 4.027e-09 200p 4.027e-09 210p 0)
IACC_B1_30 0 B1_331 pwl(0 0 50p 0 60p 4.027e-09 200p 4.027e-09 210p 0)
IACC_B1_31 0 B1_330 pwl(0 0 50p 0 60p 4.027e-09 200p 4.027e-09 210p 0)
IACC_B1_32 0 B1_329 pwl(0 0 50p 0 60p 4.027e-09 200p 4.027e-09 210p 0)
IACC_B1_33 0 B1_328 pwl(0 0 50p 0 60p 4.027e-09 200p 4.027e-09 210p 0)
IACC_B1_34 0 B1_327 pwl(0 0 50p 0 60p 4.027e-09 200p 4.027e-09 210p 0)
IACC_B1_35 0 B1_326 pwl(0 0 50p 0 60p 4.027e-09 200p 4.027e-09 210p 0)
IACC_B1_36 0 B1_325 pwl(0 0 50p 0 60p 4.027e-09 200p 4.027e-09 210p 0)
IACC_B1_37 0 B1_324 pwl(0 0 50p 0 60p 4.027e-09 200p 4.027e-09 210p 0)
IACC_B1_38 0 B1_323 pwl(0 0 50p 0 60p 4.027e-09 200p 4.027e-09 210p 0)
IACC_B1_39 0 B1_322 pwl(0 0 50p 0 60p 4.027e-09 200p 4.027e-09 210p 0)
IACC_B1_40 0 B1_321 pwl(0 0 50p 0 60p 4.027e-09 200p 4.027e-09 210p 0)
IACC_B1_41 0 B1_320 pwl(0 0 50p 0 60p 4.027e-09 200p 4.027e-09 210p 0)
IACC_B1_42 0 B1_319 pwl(0 0 50p 0 60p 4.027e-09 200p 4.027e-09 210p 0)
IACC_B1_43 0 B1_318 pwl(0 0 50p 0 60p 4.027e-09 200p 4.027e-09 210p 0)
IACC_B1_44 0 B1_317 pwl(0 0 50p 0 60p 4.027e-09 200p 4.027e-09 210p 0)
IACC_B1_45 0 B1_316 pwl(0 0 50p 0 60p 4.027e-09 200p 4.027e-09 210p 0)
IACC_B1_46 0 B1_315 pwl(0 0 50p 0 60p 4.027e-09 200p 4.027e-09 210p 0)
IACC_B1_47 0 B1_314 pwl(0 0 50p 0 60p 4.027e-09 200p 4.027e-09 210p 0)
IACC_B1_48 0 B1_313 pwl(0 0 50p 0 60p 4.027e-09 200p 4.027e-09 210p 0)
IACC_B1_49 0 B1_312 pwl(0 0 50p 0 60p 4.027e-09 200p 4.027e-09 210p 0)
BB0_0 B0_0 0 JJR area=1
CB0_0 B0_0 0 5.038e-16
LB0_0 B0_0 B0_1 6.5385e-10
BB0_1 B0_1 0 JJR area=1
CB0_1 B0_1 0 5.038e-16
LB0_1 B0_1 B0_2 6.5385e-10
BB0_2 B0_2 0 JJR area=1
CB0_2 B0_2 0 5.038e-16
LB0_2 B0_2 B0_3 6.5385e-10
BB0_3 B0_3 0 JJR area=1
CB0_3 B0_3 0 5.038e-16
LB0_3 B0_3 B0_4 6.5385e-10
BB0_4 B0_4 0 JJR area=1
CB0_4 B0_4 0 5.038e-16
LB0_4 B0_4 B0_5 6.5385e-10
BB0_5 B0_5 0 JJR area=1
CB0_5 B0_5 0 5.038e-16
LB0_5 B0_5 B0_6 6.5385e-10
BB0_6 B0_6 0 JJR area=1
CB0_6 B0_6 0 5.038e-16
LB0_6 B0_6 B0_7 6.5385e-10
BB0_7 B0_7 0 JJR area=1
CB0_7 B0_7 0 5.038e-16
LB0_7 B0_7 B0_8 6.5385e-10
BB0_8 B0_8 0 JJR area=1
CB0_8 B0_8 0 5.038e-16
LB0_8 B0_8 B0_9 6.5385e-10
BB0_9 B0_9 0 JJR area=1
CB0_9 B0_9 0 5.038e-16
LB0_9 B0_9 B0_10 6.5385e-10
BB0_10 B0_10 MB_10 JJR area=1
CB0_10 B0_10 0 5.038e-16
LB0_10 B0_10 B0_11 6.5385e-10
BB0_11 B0_11 MB_11 JJR area=1
CB0_11 B0_11 0 5.038e-16
LB0_11 B0_11 B0_12 6.5385e-10
BB0_12 B0_12 MB_12 JJR area=1
CB0_12 B0_12 0 5.038e-16
LB0_12 B0_12 B0_13 6.5385e-10
BB0_13 B0_13 MB_13 JJR area=1
CB0_13 B0_13 0 5.038e-16
LB0_13 B0_13 B0_14 6.5385e-10
BB0_14 B0_14 MB_14 JJR area=1
CB0_14 B0_14 0 5.038e-16
LB0_14 B0_14 B0_15 6.5385e-10
BB0_15 B0_15 MB_15 JJR area=1
CB0_15 B0_15 0 5.038e-16
LB0_15 B0_15 B0_16 6.5385e-10
BB0_16 B0_16 MB_16 JJR area=1
CB0_16 B0_16 0 5.038e-16
LB0_16 B0_16 B0_17 6.5385e-10
BB0_17 B0_17 MB_17 JJR area=1
CB0_17 B0_17 0 5.038e-16
LB0_17 B0_17 B0_18 6.5385e-10
BB0_18 B0_18 MB_18 JJR area=1
CB0_18 B0_18 0 5.038e-16
LB0_18 B0_18 B0_19 6.5385e-10
BB0_19 B0_19 MB_19 JJR area=1
CB0_19 B0_19 0 5.038e-16
LB0_19 B0_19 B0_20 6.5385e-10
BB0_20 B0_20 MB_20 JJR area=1
CB0_20 B0_20 0 5.038e-16
LB0_20 B0_20 B0_21 6.5385e-10
BB0_21 B0_21 MB_21 JJR area=1
CB0_21 B0_21 0 5.038e-16
LB0_21 B0_21 B0_22 6.5385e-10
BB0_22 B0_22 MB_22 JJR area=1
CB0_22 B0_22 0 5.038e-16
LB0_22 B0_22 B0_23 6.5385e-10
BB0_23 B0_23 MB_23 JJR area=1
CB0_23 B0_23 0 5.038e-16
LB0_23 B0_23 B0_24 6.5385e-10
BB0_24 B0_24 MB_24 JJR area=1
CB0_24 B0_24 0 5.038e-16
LB0_24 B0_24 B0_25 6.5385e-10
BB0_25 B0_25 MB_25 JJR area=1
CB0_25 B0_25 0 5.038e-16
LB0_25 B0_25 B0_26 6.5385e-10
BB0_26 B0_26 MB_26 JJR area=1
CB0_26 B0_26 0 5.038e-16
LB0_26 B0_26 B0_27 6.5385e-10
BB0_27 B0_27 MB_27 JJR area=1
CB0_27 B0_27 0 5.038e-16
LB0_27 B0_27 B0_28 6.5385e-10
BB0_28 B0_28 MB_28 JJR area=1
CB0_28 B0_28 0 5.038e-16
LB0_28 B0_28 B0_29 6.5385e-10
BB0_29 B0_29 MB_29 JJR area=1
CB0_29 B0_29 0 5.038e-16
LB0_29 B0_29 B0_30 6.5385e-10
BB0_30 B0_30 MB_30 JJR area=1
CB0_30 B0_30 0 5.038e-16
LB0_30 B0_30 B0_31 6.5385e-10
BB0_31 B0_31 MB_31 JJR area=1
CB0_31 B0_31 0 5.038e-16
LB0_31 B0_31 B0_32 6.5385e-10
BB0_32 B0_32 MB_32 JJR area=1
CB0_32 B0_32 0 5.038e-16
LB0_32 B0_32 B0_33 6.5385e-10
BB0_33 B0_33 MB_33 JJR area=1
CB0_33 B0_33 0 5.038e-16
LB0_33 B0_33 B0_34 6.5385e-10
BB0_34 B0_34 MB_34 JJR area=1
CB0_34 B0_34 0 5.038e-16
LB0_34 B0_34 B0_35 6.5385e-10
BB0_35 B0_35 MB_35 JJR area=1
CB0_35 B0_35 0 5.038e-16
LB0_35 B0_35 B0_36 6.5385e-10
BB0_36 B0_36 MB_36 JJR area=1
CB0_36 B0_36 0 5.038e-16
LB0_36 B0_36 B0_37 6.5385e-10
BB0_37 B0_37 MB_37 JJR area=1
CB0_37 B0_37 0 5.038e-16
LB0_37 B0_37 B0_38 6.5385e-10
BB0_38 B0_38 MB_38 JJR area=1
CB0_38 B0_38 0 5.038e-16
LB0_38 B0_38 B0_39 6.5385e-10
BB0_39 B0_39 MB_39 JJR area=1
CB0_39 B0_39 0 5.038e-16
LB0_39 B0_39 B0_40 6.5385e-10
BB0_40 B0_40 MB_40 JJR area=1
CB0_40 B0_40 0 5.038e-16
LB0_40 B0_40 B0_41 6.5385e-10
BB0_41 B0_41 MB_41 JJR area=1
CB0_41 B0_41 0 5.038e-16
LB0_41 B0_41 B0_42 6.5385e-10
BB0_42 B0_42 MB_42 JJR area=1
CB0_42 B0_42 0 5.038e-16
LB0_42 B0_42 B0_43 6.5385e-10
BB0_43 B0_43 MB_43 JJR area=1
CB0_43 B0_43 0 5.038e-16
LB0_43 B0_43 B0_44 6.5385e-10
BB0_44 B0_44 MB_44 JJR area=1
CB0_44 B0_44 0 5.038e-16
LB0_44 B0_44 B0_45 6.5385e-10
BB0_45 B0_45 MB_45 JJR area=1
CB0_45 B0_45 0 5.038e-16
LB0_45 B0_45 B0_46 6.5385e-10
BB0_46 B0_46 MB_46 JJR area=1
CB0_46 B0_46 0 5.038e-16
LB0_46 B0_46 B0_47 6.5385e-10
BB0_47 B0_47 MB_47 JJR area=1
CB0_47 B0_47 0 5.038e-16
LB0_47 B0_47 B0_48 6.5385e-10
BB0_48 B0_48 MB_48 JJR area=1
CB0_48 B0_48 0 5.038e-16
LB0_48 B0_48 B0_49 6.5385e-10
BB0_49 B0_49 MB_49 JJR area=1
CB0_49 B0_49 0 5.038e-16
LB0_49 B0_49 B0_50 6.5385e-10
BB0_50 B0_50 MB_50 JJR area=1
CB0_50 B0_50 0 5.038e-16
LB0_50 B0_50 B0_51 6.5385e-10
BB0_51 B0_51 0 JJR area=1
CB0_51 B0_51 0 5.038e-16
LB0_51 B0_51 B0_52 6.5385e-10
BB0_52 B0_52 0 JJR area=1
CB0_52 B0_52 0 5.038e-16
LB0_52 B0_52 B0_53 6.5385e-10
BB0_53 B0_53 0 JJR area=1
CB0_53 B0_53 0 5.038e-16
LB0_53 B0_53 B0_54 6.5385e-10
BB0_54 B0_54 0 JJR area=1
CB0_54 B0_54 0 5.038e-16
LB0_54 B0_54 B0_55 6.5385e-10
BB0_55 B0_55 0 JJR area=1
CB0_55 B0_55 0 5.038e-16
LB0_55 B0_55 B0_56 6.5385e-10
BB0_56 B0_56 0 JJR area=1
CB0_56 B0_56 0 5.038e-16
LB0_56 B0_56 B0_57 6.5385e-10
BB0_57 B0_57 0 JJR area=1
CB0_57 B0_57 0 5.038e-16
LB0_57 B0_57 B0_58 6.5385e-10
BB0_58 B0_58 0 JJR area=1
CB0_58 B0_58 0 5.038e-16
LB0_58 B0_58 B0_59 6.5385e-10
BB0_59 B0_59 0 JJR area=1
CB0_59 B0_59 0 5.038e-16
LB0_59 B0_59 B0_60 6.5385e-10
BB0_60 B0_60 0 JJR area=1
CB0_60 B0_60 0 5.038e-16
LB0_60 B0_60 B0_61 6.5385e-10
BB0_61 B0_61 0 JJR area=1
CB0_61 B0_61 0 5.038e-16
LB0_61 B0_61 B0_62 6.5385e-10
BB0_62 B0_62 0 JJR area=1
CB0_62 B0_62 0 5.038e-16
LB0_62 B0_62 B0_63 6.5385e-10
BB0_63 B0_63 0 JJR area=1
CB0_63 B0_63 0 5.038e-16
LB0_63 B0_63 B0_64 6.5385e-10
BB0_64 B0_64 0 JJR area=1
CB0_64 B0_64 0 5.038e-16
LB0_64 B0_64 B0_65 6.5385e-10
BB0_65 B0_65 0 JJR area=1
CB0_65 B0_65 0 5.038e-16
LB0_65 B0_65 B0_66 6.5385e-10
BB0_66 B0_66 0 JJR area=1
CB0_66 B0_66 0 5.038e-16
LB0_66 B0_66 B0_67 6.5385e-10
BB0_67 B0_67 0 JJR area=1
CB0_67 B0_67 0 5.038e-16
LB0_67 B0_67 B0_68 6.5385e-10
BB0_68 B0_68 0 JJR area=1
CB0_68 B0_68 0 5.038e-16
LB0_68 B0_68 B0_69 6.5385e-10
BB0_69 B0_69 0 JJR area=1
CB0_69 B0_69 0 5.038e-16
LB0_69 B0_69 B0_70 6.5385e-10
BB0_70 B0_70 0 JJR area=1
CB0_70 B0_70 0 5.038e-16
LB0_70 B0_70 B0_71 6.5385e-10
BB0_71 B0_71 0 JJR area=1
CB0_71 B0_71 0 5.038e-16
LB0_71 B0_71 B0_72 6.5385e-10
BB0_72 B0_72 0 JJR area=1
CB0_72 B0_72 0 5.038e-16
LB0_72 B0_72 B0_73 6.5385e-10
BB0_73 B0_73 0 JJR area=1
CB0_73 B0_73 0 5.038e-16
LB0_73 B0_73 B0_74 6.5385e-10
BB0_74 B0_74 0 JJR area=1
CB0_74 B0_74 0 5.038e-16
LB0_74 B0_74 B0_75 6.5385e-10
BB0_75 B0_75 0 JJR area=1
CB0_75 B0_75 0 5.038e-16
LB0_75 B0_75 B0_76 6.5385e-10
BB0_76 B0_76 0 JJR area=1
CB0_76 B0_76 0 5.038e-16
LB0_76 B0_76 B0_77 6.5385e-10
BB0_77 B0_77 0 JJR area=1
CB0_77 B0_77 0 5.038e-16
LB0_77 B0_77 B0_78 6.5385e-10
BB0_78 B0_78 0 JJR area=1
CB0_78 B0_78 0 5.038e-16
LB0_78 B0_78 B0_79 6.5385e-10
BB0_79 B0_79 0 JJR area=1
CB0_79 B0_79 0 5.038e-16
LB0_79 B0_79 B0_80 6.5385e-10
BB0_80 B0_80 0 JJR area=1
CB0_80 B0_80 0 5.038e-16
LB0_80 B0_80 B0_81 6.5385e-10
BB0_81 B0_81 0 JJR area=1
CB0_81 B0_81 0 5.038e-16
LB0_81 B0_81 B0_82 6.5385e-10
BB0_82 B0_82 0 JJR area=1
CB0_82 B0_82 0 5.038e-16
LB0_82 B0_82 B0_83 6.5385e-10
BB0_83 B0_83 0 JJR area=1
CB0_83 B0_83 0 5.038e-16
LB0_83 B0_83 B0_84 6.5385e-10
BB0_84 B0_84 0 JJR area=1
CB0_84 B0_84 0 5.038e-16
LB0_84 B0_84 B0_85 6.5385e-10
BB0_85 B0_85 0 JJR area=1
CB0_85 B0_85 0 5.038e-16
LB0_85 B0_85 B0_86 6.5385e-10
BB0_86 B0_86 0 JJR area=1
CB0_86 B0_86 0 5.038e-16
LB0_86 B0_86 B0_87 6.5385e-10
BB0_87 B0_87 0 JJR area=1
CB0_87 B0_87 0 5.038e-16
LB0_87 B0_87 B0_88 6.5385e-10
BB0_88 B0_88 0 JJR area=1
CB0_88 B0_88 0 5.038e-16
LB0_88 B0_88 B0_89 6.5385e-10
BB0_89 B0_89 0 JJR area=1
CB0_89 B0_89 0 5.038e-16
LB0_89 B0_89 B0_90 6.5385e-10
BB0_90 B0_90 0 JJR area=1
CB0_90 B0_90 0 5.038e-16
LB0_90 B0_90 B0_91 6.5385e-10
BB0_91 B0_91 0 JJR area=1
CB0_91 B0_91 0 5.038e-16
LB0_91 B0_91 B0_92 6.5385e-10
BB0_92 B0_92 0 JJR area=1
CB0_92 B0_92 0 5.038e-16
LB0_92 B0_92 B0_93 6.5385e-10
BB0_93 B0_93 0 JJR area=1
CB0_93 B0_93 0 5.038e-16
LB0_93 B0_93 B0_94 6.5385e-10
BB0_94 B0_94 0 JJR area=1
CB0_94 B0_94 0 5.038e-16
LB0_94 B0_94 B0_95 6.5385e-10
BB0_95 B0_95 0 JJR area=1
CB0_95 B0_95 0 5.038e-16
LB0_95 B0_95 B0_96 6.5385e-10
BB0_96 B0_96 0 JJR area=1
CB0_96 B0_96 0 5.038e-16
LB0_96 B0_96 B0_97 6.5385e-10
BB0_97 B0_97 0 JJR area=1
CB0_97 B0_97 0 5.038e-16
LB0_97 B0_97 B0_98 6.5385e-10
BB0_98 B0_98 0 JJR area=1
CB0_98 B0_98 0 5.038e-16
LB0_98 B0_98 B0_99 6.5385e-10
BB0_99 B0_99 0 JJR area=1
CB0_99 B0_99 0 5.038e-16
LB0_99 B0_99 B0_100 6.5385e-10
BB0_100 B0_100 0 JJR area=1
CB0_100 B0_100 0 5.038e-16
LB0_100 B0_100 B0_101 6.5385e-10
BB0_101 B0_101 0 JJR area=1
CB0_101 B0_101 0 5.038e-16
LB0_101 B0_101 B0_102 6.5385e-10
BB0_102 B0_102 0 JJR area=1
CB0_102 B0_102 0 5.038e-16
LB0_102 B0_102 B0_103 6.5385e-10
BB0_103 B0_103 0 JJR area=1
CB0_103 B0_103 0 5.038e-16
LB0_103 B0_103 B0_104 6.5385e-10
BB0_104 B0_104 0 JJR area=1
CB0_104 B0_104 0 5.038e-16
LB0_104 B0_104 B0_105 6.5385e-10
BB0_105 B0_105 0 JJR area=1
CB0_105 B0_105 0 5.038e-16
LB0_105 B0_105 B0_106 6.5385e-10
BB0_106 B0_106 0 JJR area=1
CB0_106 B0_106 0 5.038e-16
LB0_106 B0_106 B0_107 6.5385e-10
BB0_107 B0_107 0 JJR area=1
CB0_107 B0_107 0 5.038e-16
LB0_107 B0_107 B0_108 6.5385e-10
BB0_108 B0_108 0 JJR area=1
CB0_108 B0_108 0 5.038e-16
LB0_108 B0_108 B0_109 6.5385e-10
BB0_109 B0_109 0 JJR area=1
CB0_109 B0_109 0 5.038e-16
LB0_109 B0_109 B0_110 6.5385e-10
BB0_110 B0_110 0 JJR area=1
CB0_110 B0_110 0 5.038e-16
LB0_110 B0_110 B0_111 6.5384e-10
BB0_111 B0_111 SDB_111 JJR area=1
CB0_111 B0_111 0 5.037e-16
LB0_111 B0_111 B0_112 6.5382e-10
BB0_112 B0_112 SDB_112 JJR area=1
CB0_112 B0_112 0 5.031e-16
LB0_112 B0_112 B0_113 6.5377e-10
BB0_113 B0_113 SDB_113 JJR area=1
CB0_113 B0_113 0 5.018e-16
LB0_113 B0_113 B0_114 6.5368e-10
BB0_114 B0_114 SDB_114 JJR area=1
CB0_114 B0_114 0 4.998e-16
LB0_114 B0_114 B0_115 6.5356e-10
BB0_115 B0_115 SDB_115 JJR area=1
CB0_115 B0_115 0 4.973e-16
LB0_115 B0_115 B0_116 6.534e-10
BB0_116 B0_116 SDB_116 JJR area=1
CB0_116 B0_116 0 4.941e-16
LB0_116 B0_116 B0_117 6.5321e-10
BB0_117 B0_117 SDB_117 JJR area=1
CB0_117 B0_117 0 4.903e-16
LB0_117 B0_117 B0_118 6.5299e-10
BB0_118 B0_118 SDB_118 JJR area=1
CB0_118 B0_118 0 4.86e-16
LB0_118 B0_118 B0_119 6.5273e-10
BB0_119 B0_119 SDB_119 JJR area=1
CB0_119 B0_119 0 4.811e-16
LB0_119 B0_119 B0_120 6.5245e-10
BB0_120 B0_120 SDB_120 JJR area=1
CB0_120 B0_120 0 4.757e-16
LB0_120 B0_120 B0_121 6.5214e-10
BB0_121 B0_121 SDB_121 JJR area=1
CB0_121 B0_121 0 4.698e-16
LB0_121 B0_121 B0_122 6.5181e-10
BB0_122 B0_122 SDB_122 JJR area=1
CB0_122 B0_122 0 4.635e-16
LB0_122 B0_122 B0_123 6.5145e-10
BB0_123 B0_123 SDB_123 JJR area=1
CB0_123 B0_123 0 4.567e-16
LB0_123 B0_123 B0_124 6.5107e-10
BB0_124 B0_124 SDB_124 JJR area=1
CB0_124 B0_124 0 4.496e-16
LB0_124 B0_124 B0_125 6.5067e-10
BB0_125 B0_125 SDB_125 JJR area=1
CB0_125 B0_125 0 4.422e-16
LB0_125 B0_125 B0_126 6.5026e-10
BB0_126 B0_126 SDB_126 JJR area=1
CB0_126 B0_126 0 4.346e-16
LB0_126 B0_126 B0_127 6.4983e-10
BB0_127 B0_127 SDB_127 JJR area=1
CB0_127 B0_127 0 4.267e-16
LB0_127 B0_127 B0_128 6.4939e-10
BB0_128 B0_128 SDB_128 JJR area=1
CB0_128 B0_128 0 4.186e-16
LB0_128 B0_128 B0_129 6.4894e-10
BB0_129 B0_129 SDB_129 JJR area=1
CB0_129 B0_129 0 4.104e-16
LB0_129 B0_129 B0_130 6.4849e-10
BB0_130 B0_130 SDB_130 JJR area=1
CB0_130 B0_130 0 4.021e-16
LB0_130 B0_130 B0_131 6.4803e-10
BB0_131 B0_131 SDB_131 JJR area=1
CB0_131 B0_131 0 3.938e-16
LB0_131 B0_131 B0_132 6.4758e-10
BB0_132 B0_132 SDB_132 JJR area=1
CB0_132 B0_132 0 3.855e-16
LB0_132 B0_132 B0_133 6.4713e-10
BB0_133 B0_133 SDB_133 JJR area=1
CB0_133 B0_133 0 3.772e-16
LB0_133 B0_133 B0_134 6.4668e-10
BB0_134 B0_134 SDB_134 JJR area=1
CB0_134 B0_134 0 3.692e-16
LB0_134 B0_134 B0_135 6.4624e-10
BB0_135 B0_135 SDB_135 JJR area=1
CB0_135 B0_135 0 3.613e-16
LB0_135 B0_135 B0_136 6.4581e-10
BB0_136 B0_136 SDB_136 JJR area=1
CB0_136 B0_136 0 3.536e-16
LB0_136 B0_136 B0_137 6.454e-10
BB0_137 B0_137 SDB_137 JJR area=1
CB0_137 B0_137 0 3.462e-16
LB0_137 B0_137 B0_138 6.45e-10
BB0_138 B0_138 SDB_138 JJR area=1
CB0_138 B0_138 0 3.391e-16
LB0_138 B0_138 B0_139 6.4462e-10
BB0_139 B0_139 SDB_139 JJR area=1
CB0_139 B0_139 0 3.324e-16
LB0_139 B0_139 B0_140 6.4426e-10
BB0_140 B0_140 SDB_140 JJR area=1
CB0_140 B0_140 0 3.26e-16
LB0_140 B0_140 B0_141 6.4393e-10
BB0_141 B0_141 SDB_141 JJR area=1
CB0_141 B0_141 0 3.201e-16
LB0_141 B0_141 B0_142 6.4362e-10
BB0_142 B0_142 SDB_142 JJR area=1
CB0_142 B0_142 0 3.147e-16
LB0_142 B0_142 B0_143 6.4334e-10
BB0_143 B0_143 SDB_143 JJR area=1
CB0_143 B0_143 0 3.099e-16
LB0_143 B0_143 B0_144 6.4308e-10
BB0_144 B0_144 SDB_144 JJR area=1
CB0_144 B0_144 0 3.055e-16
LB0_144 B0_144 B0_145 6.4286e-10
BB0_145 B0_145 SDB_145 JJR area=1
CB0_145 B0_145 0 3.017e-16
LB0_145 B0_145 B0_146 6.4267e-10
BB0_146 B0_146 SDB_146 JJR area=1
CB0_146 B0_146 0 2.986e-16
LB0_146 B0_146 B0_147 6.4251e-10
BB0_147 B0_147 SDB_147 JJR area=1
CB0_147 B0_147 0 2.96e-16
LB0_147 B0_147 B0_148 6.4239e-10
BB0_148 B0_148 SDB_148 JJR area=1
CB0_148 B0_148 0 2.941e-16
LB0_148 B0_148 B0_149 6.423e-10
BB0_149 B0_149 SDB_149 JJR area=1
CB0_149 B0_149 0 2.928e-16
LB0_149 B0_149 B0_150 6.4224e-10
BB0_150 B0_150 SDB_150 JJR area=1
CB0_150 B0_150 0 2.921e-16
LB0_150 B0_150 B0_151 6.4222e-10
BB0_151 B0_151 SDB_151 JJR area=1
CB0_151 B0_151 0 2.92e-16
LB0_151 B0_151 B0_152 6.4222e-10
BB0_152 B0_152 SDB_152 JJR area=1
CB0_152 B0_152 0 2.92e-16
LB0_152 B0_152 B0_153 6.4222e-10
BB0_153 B0_153 SDB_153 JJR area=1
CB0_153 B0_153 0 2.92e-16
LB0_153 B0_153 B0_154 6.4222e-10
BB0_154 B0_154 SDB_154 JJR area=1
CB0_154 B0_154 0 2.92e-16
LB0_154 B0_154 B0_155 6.4222e-10
BB0_155 B0_155 SDB_155 JJR area=1
CB0_155 B0_155 0 2.92e-16
LB0_155 B0_155 B0_156 6.4222e-10
BB0_156 B0_156 SDB_156 JJR area=1
CB0_156 B0_156 0 2.92e-16
LB0_156 B0_156 B0_157 6.4222e-10
BB0_157 B0_157 SDB_157 JJR area=1
CB0_157 B0_157 0 2.92e-16
LB0_157 B0_157 B0_158 6.4222e-10
BB0_158 B0_158 SDB_158 JJR area=1
CB0_158 B0_158 0 2.92e-16
LB0_158 B0_158 B0_159 6.4222e-10
BB0_159 B0_159 SDB_159 JJR area=1
CB0_159 B0_159 0 2.92e-16
LB0_159 B0_159 B0_160 6.4222e-10
BB0_160 B0_160 SDB_160 JJR area=1
CB0_160 B0_160 0 2.92e-16
LB0_160 B0_160 B0_161 6.4222e-10
BB0_161 B0_161 SDB_161 JJR area=1
CB0_161 B0_161 0 2.92e-16
LB0_161 B0_161 B0_162 6.4222e-10
BB0_162 B0_162 SDB_162 JJR area=1
CB0_162 B0_162 0 2.92e-16
LB0_162 B0_162 B0_163 6.4222e-10
BB0_163 B0_163 SDB_163 JJR area=1
CB0_163 B0_163 0 2.92e-16
LB0_163 B0_163 B0_164 6.4222e-10
BB0_164 B0_164 SDB_164 JJR area=1
CB0_164 B0_164 0 2.92e-16
LB0_164 B0_164 B0_165 6.4222e-10
BB0_165 B0_165 SDB_165 JJR area=1
CB0_165 B0_165 0 2.92e-16
LB0_165 B0_165 B0_166 6.4222e-10
BB0_166 B0_166 SDB_166 JJR area=1
CB0_166 B0_166 0 2.92e-16
LB0_166 B0_166 B0_167 6.4222e-10
BB0_167 B0_167 SDB_167 JJR area=1
CB0_167 B0_167 0 2.92e-16
LB0_167 B0_167 B0_168 6.4222e-10
BB0_168 B0_168 SDB_168 JJR area=1
CB0_168 B0_168 0 2.92e-16
LB0_168 B0_168 B0_169 6.4222e-10
BB0_169 B0_169 SDB_169 JJR area=1
CB0_169 B0_169 0 2.92e-16
LB0_169 B0_169 B0_170 6.4222e-10
BB0_170 B0_170 SDB_170 JJR area=1
CB0_170 B0_170 0 2.92e-16
LB0_170 B0_170 B0_171 6.4222e-10
BB0_171 B0_171 SDB_171 JJR area=1
CB0_171 B0_171 0 2.92e-16
LB0_171 B0_171 B0_172 6.4222e-10
BB0_172 B0_172 SDB_172 JJR area=1
CB0_172 B0_172 0 2.92e-16
LB0_172 B0_172 B0_173 6.4222e-10
BB0_173 B0_173 SDB_173 JJR area=1
CB0_173 B0_173 0 2.92e-16
LB0_173 B0_173 B0_174 6.4222e-10
BB0_174 B0_174 SDB_174 JJR area=1
CB0_174 B0_174 0 2.92e-16
LB0_174 B0_174 B0_175 6.4222e-10
BB0_175 B0_175 SDB_175 JJR area=1
CB0_175 B0_175 0 2.92e-16
LB0_175 B0_175 B0_176 6.4222e-10
BB0_176 B0_176 SDB_176 JJR area=1
CB0_176 B0_176 0 2.92e-16
LB0_176 B0_176 B0_177 6.4222e-10
BB0_177 B0_177 SDB_177 JJR area=1
CB0_177 B0_177 0 2.92e-16
LB0_177 B0_177 B0_178 6.4222e-10
BB0_178 B0_178 SDB_178 JJR area=1
CB0_178 B0_178 0 2.92e-16
LB0_178 B0_178 B0_179 6.4222e-10
BB0_179 B0_179 SDB_179 JJR area=1
CB0_179 B0_179 0 2.92e-16
LB0_179 B0_179 B0_180 6.4222e-10
BB0_180 B0_180 SDB_180 JJR area=1
CB0_180 B0_180 0 2.92e-16
LB0_180 B0_180 B0_181 6.4222e-10
BB0_181 B0_181 SDB_181 JJR area=1
CB0_181 B0_181 0 2.92e-16
LB0_181 B0_181 B0_182 6.4222e-10
BB0_182 B0_182 SDB_182 JJR area=1
CB0_182 B0_182 0 2.92e-16
LB0_182 B0_182 B0_183 6.4222e-10
BB0_183 B0_183 SDB_183 JJR area=1
CB0_183 B0_183 0 2.92e-16
LB0_183 B0_183 B0_184 6.4222e-10
BB0_184 B0_184 SDB_184 JJR area=1
CB0_184 B0_184 0 2.92e-16
LB0_184 B0_184 B0_185 6.4222e-10
BB0_185 B0_185 SDB_185 JJR area=1
CB0_185 B0_185 0 2.92e-16
LB0_185 B0_185 B0_186 6.4222e-10
BB0_186 B0_186 SDB_186 JJR area=1
CB0_186 B0_186 0 2.92e-16
LB0_186 B0_186 B0_187 6.4222e-10
BB0_187 B0_187 SDB_187 JJR area=1
CB0_187 B0_187 0 2.92e-16
LB0_187 B0_187 B0_188 6.4222e-10
BB0_188 B0_188 SDB_188 JJR area=1
CB0_188 B0_188 0 2.92e-16
LB0_188 B0_188 B0_189 6.4222e-10
BB0_189 B0_189 SDB_189 JJR area=1
CB0_189 B0_189 0 2.92e-16
LB0_189 B0_189 B0_190 6.4222e-10
BB0_190 B0_190 SDB_190 JJR area=1
CB0_190 B0_190 0 2.92e-16
LB0_190 B0_190 B0_191 6.4222e-10
BB0_191 B0_191 SDB_191 JJR area=1
CB0_191 B0_191 0 2.92e-16
LB0_191 B0_191 B0_192 6.4222e-10
BB0_192 B0_192 SDB_192 JJR area=1
CB0_192 B0_192 0 2.92e-16
LB0_192 B0_192 B0_193 6.4222e-10
BB0_193 B0_193 SDB_193 JJR area=1
CB0_193 B0_193 0 2.92e-16
LB0_193 B0_193 B0_194 6.4222e-10
BB0_194 B0_194 SDB_194 JJR area=1
CB0_194 B0_194 0 2.92e-16
LB0_194 B0_194 B0_195 6.4222e-10
BB0_195 B0_195 SDB_195 JJR area=1
CB0_195 B0_195 0 2.92e-16
LB0_195 B0_195 B0_196 6.4222e-10
BB0_196 B0_196 SDB_196 JJR area=1
CB0_196 B0_196 0 2.92e-16
LB0_196 B0_196 B0_197 6.4222e-10
BB0_197 B0_197 SDB_197 JJR area=1
CB0_197 B0_197 0 2.92e-16
LB0_197 B0_197 B0_198 6.4222e-10
BB0_198 B0_198 SDB_198 JJR area=1
CB0_198 B0_198 0 2.92e-16
LB0_198 B0_198 B0_199 6.4222e-10
BB0_199 B0_199 SDB_199 JJR area=1
CB0_199 B0_199 0 2.92e-16
LB0_199 B0_199 B0_200 6.4222e-10
BB0_200 B0_200 SDB_200 JJR area=1
CB0_200 B0_200 0 2.92e-16
LB0_200 B0_200 B0_201 6.4222e-10
BB0_201 B0_201 SDB_201 JJR area=1
CB0_201 B0_201 0 2.92e-16
LB0_201 B0_201 B0_202 6.4222e-10
BB0_202 B0_202 SDB_202 JJR area=1
CB0_202 B0_202 0 2.92e-16
LB0_202 B0_202 B0_203 6.4222e-10
BB0_203 B0_203 SDB_203 JJR area=1
CB0_203 B0_203 0 2.92e-16
LB0_203 B0_203 B0_204 6.4222e-10
BB0_204 B0_204 SDB_204 JJR area=1
CB0_204 B0_204 0 2.92e-16
LB0_204 B0_204 B0_205 6.4222e-10
BB0_205 B0_205 SDB_205 JJR area=1
CB0_205 B0_205 0 2.92e-16
LB0_205 B0_205 B0_206 6.4222e-10
BB0_206 B0_206 SDB_206 JJR area=1
CB0_206 B0_206 0 2.92e-16
LB0_206 B0_206 B0_207 6.4222e-10
BB0_207 B0_207 SDB_207 JJR area=1
CB0_207 B0_207 0 2.92e-16
LB0_207 B0_207 B0_208 6.4222e-10
BB0_208 B0_208 SDB_208 JJR area=1
CB0_208 B0_208 0 2.92e-16
LB0_208 B0_208 B0_209 6.4222e-10
BB0_209 B0_209 SDB_209 JJR area=1
CB0_209 B0_209 0 2.92e-16
LB0_209 B0_209 B0_210 6.4222e-10
BB0_210 B0_210 SDB_210 JJR area=1
CB0_210 B0_210 0 2.92e-16
LB0_210 B0_210 B0_211 6.4222e-10
BB0_211 B0_211 SDB_211 JJR area=1
CB0_211 B0_211 0 2.92e-16
LB0_211 B0_211 B0_212 6.4222e-10
BB0_212 B0_212 SDB_212 JJR area=1
CB0_212 B0_212 0 2.92e-16
LB0_212 B0_212 B0_213 6.4222e-10
BB0_213 B0_213 SDB_213 JJR area=1
CB0_213 B0_213 0 2.92e-16
LB0_213 B0_213 B0_214 6.4222e-10
BB0_214 B0_214 SDB_214 JJR area=1
CB0_214 B0_214 0 2.92e-16
LB0_214 B0_214 B0_215 6.4222e-10
BB0_215 B0_215 SDB_215 JJR area=1
CB0_215 B0_215 0 2.92e-16
LB0_215 B0_215 B0_216 6.4222e-10
BB0_216 B0_216 SDB_216 JJR area=1
CB0_216 B0_216 0 2.92e-16
LB0_216 B0_216 B0_217 6.4222e-10
BB0_217 B0_217 SDB_217 JJR area=1
CB0_217 B0_217 0 2.92e-16
LB0_217 B0_217 B0_218 6.4222e-10
BB0_218 B0_218 SDB_218 JJR area=1
CB0_218 B0_218 0 2.92e-16
LB0_218 B0_218 B0_219 6.4222e-10
BB0_219 B0_219 SDB_219 JJR area=1
CB0_219 B0_219 0 2.92e-16
LB0_219 B0_219 B0_220 6.4222e-10
BB0_220 B0_220 SDB_220 JJR area=1
CB0_220 B0_220 0 2.92e-16
LB0_220 B0_220 B0_221 6.4222e-10
BB0_221 B0_221 SDB_221 JJR area=1
CB0_221 B0_221 0 2.92e-16
LB0_221 B0_221 B0_222 6.4222e-10
BB0_222 B0_222 SDB_222 JJR area=1
CB0_222 B0_222 0 2.92e-16
LB0_222 B0_222 B0_223 6.4222e-10
BB0_223 B0_223 SDB_223 JJR area=1
CB0_223 B0_223 0 2.92e-16
LB0_223 B0_223 B0_224 6.4222e-10
BB0_224 B0_224 SDB_224 JJR area=1
CB0_224 B0_224 0 2.92e-16
LB0_224 B0_224 B0_225 6.4222e-10
BB0_225 B0_225 SDB_225 JJR area=1
CB0_225 B0_225 0 2.92e-16
LB0_225 B0_225 B0_226 6.4222e-10
BB0_226 B0_226 SDB_226 JJR area=1
CB0_226 B0_226 0 2.92e-16
LB0_226 B0_226 B0_227 6.4222e-10
BB0_227 B0_227 SDB_227 JJR area=1
CB0_227 B0_227 0 2.92e-16
LB0_227 B0_227 B0_228 6.4222e-10
BB0_228 B0_228 SDB_228 JJR area=1
CB0_228 B0_228 0 2.92e-16
LB0_228 B0_228 B0_229 6.4222e-10
BB0_229 B0_229 SDB_229 JJR area=1
CB0_229 B0_229 0 2.92e-16
LB0_229 B0_229 B0_230 6.4222e-10
BB0_230 B0_230 SDB_230 JJR area=1
CB0_230 B0_230 0 2.92e-16
LB0_230 B0_230 B0_231 6.4222e-10
BB0_231 B0_231 SDB_231 JJR area=1
CB0_231 B0_231 0 2.92e-16
LB0_231 B0_231 B0_232 6.4222e-10
BB0_232 B0_232 SDB_232 JJR area=1
CB0_232 B0_232 0 2.92e-16
LB0_232 B0_232 B0_233 6.4222e-10
BB0_233 B0_233 SDB_233 JJR area=1
CB0_233 B0_233 0 2.92e-16
LB0_233 B0_233 B0_234 6.4222e-10
BB0_234 B0_234 SDB_234 JJR area=1
CB0_234 B0_234 0 2.92e-16
LB0_234 B0_234 B0_235 6.4222e-10
BB0_235 B0_235 SDB_235 JJR area=1
CB0_235 B0_235 0 2.92e-16
LB0_235 B0_235 B0_236 6.4222e-10
BB0_236 B0_236 SDB_236 JJR area=1
CB0_236 B0_236 0 2.92e-16
LB0_236 B0_236 B0_237 6.4222e-10
BB0_237 B0_237 SDB_237 JJR area=1
CB0_237 B0_237 0 2.92e-16
LB0_237 B0_237 B0_238 6.4222e-10
BB0_238 B0_238 SDB_238 JJR area=1
CB0_238 B0_238 0 2.92e-16
LB0_238 B0_238 B0_239 6.4222e-10
BB0_239 B0_239 SDB_239 JJR area=1
CB0_239 B0_239 0 2.92e-16
LB0_239 B0_239 B0_240 6.4222e-10
BB0_240 B0_240 SDB_240 JJR area=1
CB0_240 B0_240 0 2.92e-16
LB0_240 B0_240 B0_241 6.4222e-10
BB0_241 B0_241 SDB_241 JJR area=1
CB0_241 B0_241 0 2.92e-16
LB0_241 B0_241 B0_242 6.4222e-10
BB0_242 B0_242 SDB_242 JJR area=1
CB0_242 B0_242 0 2.92e-16
LB0_242 B0_242 B0_243 6.4222e-10
BB0_243 B0_243 SDB_243 JJR area=1
CB0_243 B0_243 0 2.92e-16
LB0_243 B0_243 B0_244 6.4222e-10
BB0_244 B0_244 SDB_244 JJR area=1
CB0_244 B0_244 0 2.92e-16
LB0_244 B0_244 B0_245 6.4222e-10
BB0_245 B0_245 SDB_245 JJR area=1
CB0_245 B0_245 0 2.92e-16
LB0_245 B0_245 B0_246 6.4222e-10
BB0_246 B0_246 SDB_246 JJR area=1
CB0_246 B0_246 0 2.92e-16
LB0_246 B0_246 B0_247 6.4222e-10
BB0_247 B0_247 SDB_247 JJR area=1
CB0_247 B0_247 0 2.92e-16
LB0_247 B0_247 B0_248 6.4222e-10
BB0_248 B0_248 SDB_248 JJR area=1
CB0_248 B0_248 0 2.92e-16
LB0_248 B0_248 B0_249 6.4222e-10
BB0_249 B0_249 SDB_249 JJR area=1
CB0_249 B0_249 0 2.92e-16
LB0_249 B0_249 B0_250 6.4222e-10
BB0_250 B0_250 SDB_250 JJR area=1
CB0_250 B0_250 0 2.92e-16
LB0_250 B0_250 B0_251 6.4222e-10
BB0_251 B0_251 SDB_251 JJR area=1
CB0_251 B0_251 0 2.921e-16
LB0_251 B0_251 B0_252 6.4224e-10
BB0_252 B0_252 SDB_252 JJR area=1
CB0_252 B0_252 0 2.928e-16
LB0_252 B0_252 B0_253 6.423e-10
BB0_253 B0_253 SDB_253 JJR area=1
CB0_253 B0_253 0 2.941e-16
LB0_253 B0_253 B0_254 6.4239e-10
BB0_254 B0_254 SDB_254 JJR area=1
CB0_254 B0_254 0 2.96e-16
LB0_254 B0_254 B0_255 6.4251e-10
BB0_255 B0_255 SDB_255 JJR area=1
CB0_255 B0_255 0 2.986e-16
LB0_255 B0_255 B0_256 6.4267e-10
BB0_256 B0_256 SDB_256 JJR area=1
CB0_256 B0_256 0 3.017e-16
LB0_256 B0_256 B0_257 6.4286e-10
BB0_257 B0_257 SDB_257 JJR area=1
CB0_257 B0_257 0 3.055e-16
LB0_257 B0_257 B0_258 6.4308e-10
BB0_258 B0_258 SDB_258 JJR area=1
CB0_258 B0_258 0 3.099e-16
LB0_258 B0_258 B0_259 6.4334e-10
BB0_259 B0_259 SDB_259 JJR area=1
CB0_259 B0_259 0 3.147e-16
LB0_259 B0_259 B0_260 6.4362e-10
BB0_260 B0_260 SDB_260 JJR area=1
CB0_260 B0_260 0 3.201e-16
LB0_260 B0_260 B0_261 6.4393e-10
BB0_261 B0_261 SDB_261 JJR area=1
CB0_261 B0_261 0 3.26e-16
LB0_261 B0_261 B0_262 6.4426e-10
BB0_262 B0_262 SDB_262 JJR area=1
CB0_262 B0_262 0 3.324e-16
LB0_262 B0_262 B0_263 6.4462e-10
BB0_263 B0_263 SDB_263 JJR area=1
CB0_263 B0_263 0 3.391e-16
LB0_263 B0_263 B0_264 6.45e-10
BB0_264 B0_264 SDB_264 JJR area=1
CB0_264 B0_264 0 3.462e-16
LB0_264 B0_264 B0_265 6.454e-10
BB0_265 B0_265 SDB_265 JJR area=1
CB0_265 B0_265 0 3.536e-16
LB0_265 B0_265 B0_266 6.4581e-10
BB0_266 B0_266 SDB_266 JJR area=1
CB0_266 B0_266 0 3.613e-16
LB0_266 B0_266 B0_267 6.4624e-10
BB0_267 B0_267 SDB_267 JJR area=1
CB0_267 B0_267 0 3.692e-16
LB0_267 B0_267 B0_268 6.4668e-10
BB0_268 B0_268 SDB_268 JJR area=1
CB0_268 B0_268 0 3.772e-16
LB0_268 B0_268 B0_269 6.4713e-10
BB0_269 B0_269 SDB_269 JJR area=1
CB0_269 B0_269 0 3.855e-16
LB0_269 B0_269 B0_270 6.4758e-10
BB0_270 B0_270 SDB_270 JJR area=1
CB0_270 B0_270 0 3.938e-16
LB0_270 B0_270 B0_271 6.4803e-10
BB0_271 B0_271 SDB_271 JJR area=1
CB0_271 B0_271 0 4.021e-16
LB0_271 B0_271 B0_272 6.4849e-10
BB0_272 B0_272 SDB_272 JJR area=1
CB0_272 B0_272 0 4.104e-16
LB0_272 B0_272 B0_273 6.4894e-10
BB0_273 B0_273 SDB_273 JJR area=1
CB0_273 B0_273 0 4.186e-16
LB0_273 B0_273 B0_274 6.4939e-10
BB0_274 B0_274 SDB_274 JJR area=1
CB0_274 B0_274 0 4.267e-16
LB0_274 B0_274 B0_275 6.4983e-10
BB0_275 B0_275 SDB_275 JJR area=1
CB0_275 B0_275 0 4.346e-16
LB0_275 B0_275 B0_276 6.5026e-10
BB0_276 B0_276 SDB_276 JJR area=1
CB0_276 B0_276 0 4.422e-16
LB0_276 B0_276 B0_277 6.5067e-10
BB0_277 B0_277 SDB_277 JJR area=1
CB0_277 B0_277 0 4.496e-16
LB0_277 B0_277 B0_278 6.5107e-10
BB0_278 B0_278 SDB_278 JJR area=1
CB0_278 B0_278 0 4.567e-16
LB0_278 B0_278 B0_279 6.5145e-10
BB0_279 B0_279 SDB_279 JJR area=1
CB0_279 B0_279 0 4.635e-16
LB0_279 B0_279 B0_280 6.5181e-10
BB0_280 B0_280 SDB_280 JJR area=1
CB0_280 B0_280 0 4.698e-16
LB0_280 B0_280 B0_281 6.5214e-10
BB0_281 B0_281 SDB_281 JJR area=1
CB0_281 B0_281 0 4.757e-16
LB0_281 B0_281 B0_282 6.5245e-10
BB0_282 B0_282 SDB_282 JJR area=1
CB0_282 B0_282 0 4.811e-16
LB0_282 B0_282 B0_283 6.5273e-10
BB0_283 B0_283 SDB_283 JJR area=1
CB0_283 B0_283 0 4.86e-16
LB0_283 B0_283 B0_284 6.5299e-10
BB0_284 B0_284 SDB_284 JJR area=1
CB0_284 B0_284 0 4.903e-16
LB0_284 B0_284 B0_285 6.5321e-10
BB0_285 B0_285 SDB_285 JJR area=1
CB0_285 B0_285 0 4.941e-16
LB0_285 B0_285 B0_286 6.534e-10
BB0_286 B0_286 SDB_286 JJR area=1
CB0_286 B0_286 0 4.973e-16
LB0_286 B0_286 B0_287 6.5356e-10
BB0_287 B0_287 SDB_287 JJR area=1
CB0_287 B0_287 0 4.998e-16
LB0_287 B0_287 B0_288 6.5368e-10
BB0_288 B0_288 SDB_288 JJR area=1
CB0_288 B0_288 0 5.018e-16
LB0_288 B0_288 B0_289 6.5377e-10
BB0_289 B0_289 SDB_289 JJR area=1
CB0_289 B0_289 0 5.031e-16
LB0_289 B0_289 B0_290 6.5382e-10
BB0_290 B0_290 SDB_290 JJR area=1
CB0_290 B0_290 0 5.037e-16
LB0_290 B0_290 B0_291 6.5384e-10
BB0_291 B0_291 MB_291 JJR area=1
CB0_291 B0_291 0 5.038e-16
LB0_291 B0_291 B0_292 6.5385e-10
BB0_292 B0_292 MB_292 JJR area=1
CB0_292 B0_292 0 5.038e-16
LB0_292 B0_292 B0_293 6.5385e-10
BB0_293 B0_293 MB_293 JJR area=1
CB0_293 B0_293 0 5.038e-16
LB0_293 B0_293 B0_294 6.5385e-10
BB0_294 B0_294 MB_294 JJR area=1
CB0_294 B0_294 0 5.038e-16
LB0_294 B0_294 B0_295 6.5385e-10
BB0_295 B0_295 MB_295 JJR area=1
CB0_295 B0_295 0 5.038e-16
LB0_295 B0_295 B0_296 6.5385e-10
BB0_296 B0_296 MB_296 JJR area=1
CB0_296 B0_296 0 5.038e-16
LB0_296 B0_296 B0_297 6.5385e-10
BB0_297 B0_297 MB_297 JJR area=1
CB0_297 B0_297 0 5.038e-16
LB0_297 B0_297 B0_298 6.5385e-10
BB0_298 B0_298 MB_298 JJR area=1
CB0_298 B0_298 0 5.038e-16
LB0_298 B0_298 B0_299 6.5385e-10
BB0_299 B0_299 MB_299 JJR area=1
CB0_299 B0_299 0 5.038e-16
LB0_299 B0_299 B0_300 6.5385e-10
BB0_300 B0_300 MB_300 JJR area=1
CB0_300 B0_300 0 5.038e-16
LB0_300 B0_300 B0_301 6.5385e-10
BB0_301 B0_301 MB_301 JJR area=1
CB0_301 B0_301 0 5.038e-16
LB0_301 B0_301 B0_302 6.5385e-10
BB0_302 B0_302 MB_302 JJR area=1
CB0_302 B0_302 0 5.038e-16
LB0_302 B0_302 B0_303 6.5385e-10
BB0_303 B0_303 MB_303 JJR area=1
CB0_303 B0_303 0 5.038e-16
LB0_303 B0_303 B0_304 6.5385e-10
BB0_304 B0_304 MB_304 JJR area=1
CB0_304 B0_304 0 5.038e-16
LB0_304 B0_304 B0_305 6.5385e-10
BB0_305 B0_305 MB_305 JJR area=1
CB0_305 B0_305 0 5.038e-16
LB0_305 B0_305 B0_306 6.5385e-10
BB0_306 B0_306 MB_306 JJR area=1
CB0_306 B0_306 0 5.038e-16
LB0_306 B0_306 B0_307 6.5385e-10
BB0_307 B0_307 MB_307 JJR area=1
CB0_307 B0_307 0 5.038e-16
LB0_307 B0_307 B0_308 6.5385e-10
BB0_308 B0_308 MB_308 JJR area=1
CB0_308 B0_308 0 5.038e-16
LB0_308 B0_308 B0_309 6.5385e-10
BB0_309 B0_309 MB_309 JJR area=1
CB0_309 B0_309 0 5.038e-16
LB0_309 B0_309 B0_310 6.5385e-10
BB0_310 B0_310 MB_310 JJR area=1
CB0_310 B0_310 0 5.038e-16
LB0_310 B0_310 B0_311 6.5385e-10
BB0_311 B0_311 MB_311 JJR area=1
CB0_311 B0_311 0 5.038e-16
LB0_311 B0_311 B0_312 6.5385e-10
BB0_312 B0_312 0 JJR area=1
CB0_312 B0_312 0 5.038e-16
LB0_312 B0_312 B0_313 6.5385e-10
BB0_313 B0_313 0 JJR area=1
CB0_313 B0_313 0 5.038e-16
LB0_313 B0_313 B0_314 6.5385e-10
BB0_314 B0_314 0 JJR area=1
CB0_314 B0_314 0 5.038e-16
LB0_314 B0_314 B0_315 6.5385e-10
BB0_315 B0_315 0 JJR area=1
CB0_315 B0_315 0 5.038e-16
LB0_315 B0_315 B0_316 6.5385e-10
BB0_316 B0_316 0 JJR area=1
CB0_316 B0_316 0 5.038e-16
LB0_316 B0_316 B0_317 6.5385e-10
BB0_317 B0_317 0 JJR area=1
CB0_317 B0_317 0 5.038e-16
LB0_317 B0_317 B0_318 6.5385e-10
BB0_318 B0_318 0 JJR area=1
CB0_318 B0_318 0 5.038e-16
LB0_318 B0_318 B0_319 6.5385e-10
BB0_319 B0_319 0 JJR area=1
CB0_319 B0_319 0 5.038e-16
LB0_319 B0_319 B0_320 6.5385e-10
BB0_320 B0_320 0 JJR area=1
CB0_320 B0_320 0 5.038e-16
LB0_320 B0_320 B0_321 6.5385e-10
BB0_321 B0_321 0 JJR area=1
CB0_321 B0_321 0 5.038e-16
LB0_321 B0_321 B0_322 6.5385e-10
BB0_322 B0_322 0 JJR area=1
CB0_322 B0_322 0 5.038e-16
LB0_322 B0_322 B0_323 6.5385e-10
BB0_323 B0_323 0 JJR area=1
CB0_323 B0_323 0 5.038e-16
LB0_323 B0_323 B0_324 6.5385e-10
BB0_324 B0_324 0 JJR area=1
CB0_324 B0_324 0 5.038e-16
LB0_324 B0_324 B0_325 6.5385e-10
BB0_325 B0_325 0 JJR area=1
CB0_325 B0_325 0 5.038e-16
LB0_325 B0_325 B0_326 6.5385e-10
BB0_326 B0_326 0 JJR area=1
CB0_326 B0_326 0 5.038e-16
LB0_326 B0_326 B0_327 6.5385e-10
BB0_327 B0_327 0 JJR area=1
CB0_327 B0_327 0 5.038e-16
LB0_327 B0_327 B0_328 6.5385e-10
BB0_328 B0_328 0 JJR area=1
CB0_328 B0_328 0 5.038e-16
LB0_328 B0_328 B0_329 6.5385e-10
BB0_329 B0_329 0 JJR area=1
CB0_329 B0_329 0 5.038e-16
LB0_329 B0_329 B0_330 6.5385e-10
BB0_330 B0_330 0 JJR area=1
CB0_330 B0_330 0 5.038e-16
LB0_330 B0_330 B0_331 6.5385e-10
BB0_331 B0_331 0 JJR area=1
CB0_331 B0_331 0 5.038e-16
LB0_331 B0_331 B0_332 6.5385e-10
BB0_332 B0_332 0 JJR area=1
CB0_332 B0_332 0 5.038e-16
LB0_332 B0_332 B0_333 6.5385e-10
BB0_333 B0_333 0 JJR area=1
CB0_333 B0_333 0 5.038e-16
LB0_333 B0_333 B0_334 6.5385e-10
BB0_334 B0_334 0 JJR area=1
CB0_334 B0_334 0 5.038e-16
LB0_334 B0_334 B0_335 6.5385e-10
BB0_335 B0_335 0 JJR area=1
CB0_335 B0_335 0 5.038e-16
LB0_335 B0_335 B0_336 6.5385e-10
BB0_336 B0_336 0 JJR area=1
CB0_336 B0_336 0 5.038e-16
LB0_336 B0_336 B0_337 6.5385e-10
BB0_337 B0_337 0 JJR area=1
CB0_337 B0_337 0 5.038e-16
LB0_337 B0_337 B0_338 6.5385e-10
BB0_338 B0_338 0 JJR area=1
CB0_338 B0_338 0 5.038e-16
LB0_338 B0_338 B0_339 6.5385e-10
BB0_339 B0_339 0 JJR area=1
CB0_339 B0_339 0 5.038e-16
LB0_339 B0_339 B0_340 6.5385e-10
BB0_340 B0_340 0 JJR area=1
CB0_340 B0_340 0 5.038e-16
LB0_340 B0_340 B0_341 6.5385e-10
BB0_341 B0_341 0 JJR area=1
CB0_341 B0_341 0 5.038e-16
LB0_341 B0_341 B0_342 6.5385e-10
BB0_342 B0_342 0 JJR area=1
CB0_342 B0_342 0 5.038e-16
LB0_342 B0_342 B0_343 6.5385e-10
BB0_343 B0_343 0 JJR area=1
CB0_343 B0_343 0 5.038e-16
LB0_343 B0_343 B0_344 6.5385e-10
BB0_344 B0_344 0 JJR area=1
CB0_344 B0_344 0 5.038e-16
LB0_344 B0_344 B0_345 6.5385e-10
BB0_345 B0_345 0 JJR area=1
CB0_345 B0_345 0 5.038e-16
LB0_345 B0_345 B0_346 6.5385e-10
BB0_346 B0_346 0 JJR area=1
CB0_346 B0_346 0 5.038e-16
LB0_346 B0_346 B0_347 6.5385e-10
BB0_347 B0_347 0 JJR area=1
CB0_347 B0_347 0 5.038e-16
LB0_347 B0_347 B0_348 6.5385e-10
BB0_348 B0_348 0 JJR area=1
CB0_348 B0_348 0 5.038e-16
LB0_348 B0_348 B0_349 6.5385e-10
BB0_349 B0_349 0 JJR area=1
CB0_349 B0_349 0 5.038e-16
LB0_349 B0_349 B0_350 6.5385e-10
BB0_350 B0_350 0 JJR area=1
CB0_350 B0_350 0 5.038e-16
LB0_350 B0_350 B0_351 6.5385e-10
BB0_351 B0_351 0 JJR area=1
CB0_351 B0_351 0 5.038e-16
LB0_351 B0_351 B0_352 6.5385e-10
BB0_352 B0_352 0 JJR area=1
CB0_352 B0_352 0 5.038e-16
LB0_352 B0_352 B0_353 6.5385e-10
BB0_353 B0_353 0 JJR area=1
CB0_353 B0_353 0 5.038e-16
LB0_353 B0_353 B0_354 6.5385e-10
BB0_354 B0_354 0 JJR area=1
CB0_354 B0_354 0 5.038e-16
LB0_354 B0_354 B0_355 6.5385e-10
BB0_355 B0_355 0 JJR area=1
CB0_355 B0_355 0 5.038e-16
LB0_355 B0_355 B0_356 6.5385e-10
BB0_356 B0_356 0 JJR area=1
CB0_356 B0_356 0 5.038e-16
LB0_356 B0_356 B0_357 6.5385e-10
BB0_357 B0_357 0 JJR area=1
CB0_357 B0_357 0 5.038e-16
LB0_357 B0_357 B0_358 6.5385e-10
BB0_358 B0_358 0 JJR area=1
CB0_358 B0_358 0 5.038e-16
LB0_358 B0_358 B0_359 6.5385e-10
BB0_359 B0_359 0 JJR area=1
CB0_359 B0_359 0 5.038e-16
LB0_359 B0_359 B0_360 6.5385e-10
BB0_360 B0_360 0 JJR area=1
CB0_360 B0_360 0 5.038e-16
LB0_360 B0_360 B0_361 6.5385e-10
BB0_361 B0_361 0 JJR area=1
CB0_361 B0_361 0 5.038e-16
BINJ_B0 B0_361 0 JJI area=1
IINJ_B0 0 B0_361 pwl(0 0 20p 0 30p 1.933e-07 50p 0)
LCATCH_B0 B0_0 0 20n
IACC_B0_10 0 B0_351 pwl(0 0 50p 0 60p 4.027e-09 200p 4.027e-09 210p 0)
IACC_B0_11 0 B0_350 pwl(0 0 50p 0 60p 4.027e-09 200p 4.027e-09 210p 0)
IACC_B0_12 0 B0_349 pwl(0 0 50p 0 60p 4.027e-09 200p 4.027e-09 210p 0)
IACC_B0_13 0 B0_348 pwl(0 0 50p 0 60p 4.027e-09 200p 4.027e-09 210p 0)
IACC_B0_14 0 B0_347 pwl(0 0 50p 0 60p 4.027e-09 200p 4.027e-09 210p 0)
IACC_B0_15 0 B0_346 pwl(0 0 50p 0 60p 4.027e-09 200p 4.027e-09 210p 0)
IACC_B0_16 0 B0_345 pwl(0 0 50p 0 60p 4.027e-09 200p 4.027e-09 210p 0)
IACC_B0_17 0 B0_344 pwl(0 0 50p 0 60p 4.027e-09 200p 4.027e-09 210p 0)
IACC_B0_18 0 B0_343 pwl(0 0 50p 0 60p 4.027e-09 200p 4.027e-09 210p 0)
IACC_B0_19 0 B0_342 pwl(0 0 50p 0 60p 4.027e-09 200p 4.027e-09 210p 0)
IACC_B0_20 0 B0_341 pwl(0 0 50p 0 60p 4.027e-09 200p 4.027e-09 210p 0)
IACC_B0_21 0 B0_340 pwl(0 0 50p 0 60p 4.027e-09 200p 4.027e-09 210p 0)
IACC_B0_22 0 B0_339 pwl(0 0 50p 0 60p 4.027e-09 200p 4.027e-09 210p 0)
IACC_B0_23 0 B0_338 pwl(0 0 50p 0 60p 4.027e-09 200p 4.027e-09 210p 0)
IACC_B0_24 0 B0_337 pwl(0 0 50p 0 60p 4.027e-09 200p 4.027e-09 210p 0)
IACC_B0_25 0 B0_336 pwl(0 0 50p 0 60p 4.027e-09 200p 4.027e-09 210p 0)
IACC_B0_26 0 B0_335 pwl(0 0 50p 0 60p 4.027e-09 200p 4.027e-09 210p 0)
IACC_B0_27 0 B0_334 pwl(0 0 50p 0 60p 4.027e-09 200p 4.027e-09 210p 0)
IACC_B0_28 0 B0_333 pwl(0 0 50p 0 60p 4.027e-09 200p 4.027e-09 210p 0)
IACC_B0_29 0 B0_332 pwl(0 0 50p 0 60p 4.027e-09 200p 4.027e-09 210p 0)
IACC_B0_30 0 B0_331 pwl(0 0 50p 0 60p 4.027e-09 200p 4.027e-09 210p 0)
IACC_B0_31 0 B0_330 pwl(0 0 50p 0 60p 4.027e-09 200p 4.027e-09 210p 0)
IACC_B0_32 0 B0_329 pwl(0 0 50p 0 60p 4.027e-09 200p 4.027e-09 210p 0)
IACC_B0_33 0 B0_328 pwl(0 0 50p 0 60p 4.027e-09 200p 4.027e-09 210p 0)
IACC_B0_34 0 B0_327 pwl(0 0 50p 0 60p 4.027e-09 200p 4.027e-09 210p 0)
IACC_B0_35 0 B0_326 pwl(0 0 50p 0 60p 4.027e-09 200p 4.027e-09 210p 0)
IACC_B0_36 0 B0_325 pwl(0 0 50p 0 60p 4.027e-09 200p 4.027e-09 210p 0)
IACC_B0_37 0 B0_324 pwl(0 0 50p 0 60p 4.027e-09 200p 4.027e-09 210p 0)
IACC_B0_38 0 B0_323 pwl(0 0 50p 0 60p 4.027e-09 200p 4.027e-09 210p 0)
IACC_B0_39 0 B0_322 pwl(0 0 50p 0 60p 4.027e-09 200p 4.027e-09 210p 0)
IACC_B0_40 0 B0_321 pwl(0 0 50p 0 60p 4.027e-09 200p 4.027e-09 210p 0)
IACC_B0_41 0 B0_320 pwl(0 0 50p 0 60p 4.027e-09 200p 4.027e-09 210p 0)
IACC_B0_42 0 B0_319 pwl(0 0 50p 0 60p 4.027e-09 200p 4.027e-09 210p 0)
IACC_B0_43 0 B0_318 pwl(0 0 50p 0 60p 4.027e-09 200p 4.027e-09 210p 0)
IACC_B0_44 0 B0_317 pwl(0 0 50p 0 60p 4.027e-09 200p 4.027e-09 210p 0)
IACC_B0_45 0 B0_316 pwl(0 0 50p 0 60p 4.027e-09 200p 4.027e-09 210p 0)
IACC_B0_46 0 B0_315 pwl(0 0 50p 0 60p 4.027e-09 200p 4.027e-09 210p 0)
IACC_B0_47 0 B0_314 pwl(0 0 50p 0 60p 4.027e-09 200p 4.027e-09 210p 0)
IACC_B0_48 0 B0_313 pwl(0 0 50p 0 60p 4.027e-09 200p 4.027e-09 210p 0)
IACC_B0_49 0 B0_312 pwl(0 0 50p 0 60p 4.027e-09 200p 4.027e-09 210p 0)
BD_B_0 D_B_0 0 JJR area=1
CD_B_0 D_B_0 0 5.038e-16
LD_B_0 D_B_0 D_B_1 6.5385e-10
BD_B_1 D_B_1 0 JJR area=1
CD_B_1 D_B_1 0 5.038e-16
LD_B_1 D_B_1 D_B_2 6.5385e-10
BD_B_2 D_B_2 0 JJR area=1
CD_B_2 D_B_2 0 5.038e-16
LD_B_2 D_B_2 D_B_3 6.5385e-10
BD_B_3 D_B_3 0 JJR area=1
CD_B_3 D_B_3 0 5.038e-16
LD_B_3 D_B_3 D_B_4 6.5385e-10
BD_B_4 D_B_4 0 JJR area=1
CD_B_4 D_B_4 0 5.038e-16
LD_B_4 D_B_4 D_B_5 6.5385e-10
BD_B_5 D_B_5 0 JJR area=1
CD_B_5 D_B_5 0 5.038e-16
LD_B_5 D_B_5 D_B_6 6.5385e-10
BD_B_6 D_B_6 0 JJR area=1
CD_B_6 D_B_6 0 5.038e-16
LD_B_6 D_B_6 D_B_7 6.5385e-10
BD_B_7 D_B_7 0 JJR area=1
CD_B_7 D_B_7 0 5.038e-16
LD_B_7 D_B_7 D_B_8 6.5385e-10
BD_B_8 D_B_8 0 JJR area=1
CD_B_8 D_B_8 0 5.038e-16
LD_B_8 D_B_8 D_B_9 6.5385e-10
BD_B_9 D_B_9 0 JJR area=1
CD_B_9 D_B_9 0 5.038e-16
LD_B_9 D_B_9 D_B_10 6.5385e-10
BD_B_10 D_B_10 0 JJR area=1
CD_B_10 D_B_10 0 5.038e-16
LD_B_10 D_B_10 D_B_11 6.5385e-10
BD_B_11 D_B_11 0 JJR area=1
CD_B_11 D_B_11 0 5.038e-16
LD_B_11 D_B_11 D_B_12 6.5385e-10
BD_B_12 D_B_12 0 JJR area=1
CD_B_12 D_B_12 0 5.038e-16
LD_B_12 D_B_12 D_B_13 6.5385e-10
BD_B_13 D_B_13 0 JJR area=1
CD_B_13 D_B_13 0 5.038e-16
LD_B_13 D_B_13 D_B_14 6.5385e-10
BD_B_14 D_B_14 0 JJR area=1
CD_B_14 D_B_14 0 5.038e-16
LD_B_14 D_B_14 D_B_15 6.5385e-10
BD_B_15 D_B_15 0 JJR area=1
CD_B_15 D_B_15 0 5.038e-16
LD_B_15 D_B_15 D_B_16 6.5385e-10
BD_B_16 D_B_16 0 JJR area=1
CD_B_16 D_B_16 0 5.038e-16
LD_B_16 D_B_16 D_B_17 6.5385e-10
BD_B_17 D_B_17 0 JJR area=1
CD_B_17 D_B_17 0 5.038e-16
LD_B_17 D_B_17 D_B_18 6.5385e-10
BD_B_18 D_B_18 0 JJR area=1
CD_B_18 D_B_18 0 5.038e-16
LD_B_18 D_B_18 D_B_19 6.5385e-10
BD_B_19 D_B_19 0 JJR area=1
CD_B_19 D_B_19 0 5.038e-16
LD_B_19 D_B_19 D_B_20 6.5385e-10
BD_B_20 D_B_20 0 JJR area=1
CD_B_20 D_B_20 0 5.038e-16
LD_B_20 D_B_20 D_B_21 6.5385e-10
BD_B_21 D_B_21 0 JJR area=1
CD_B_21 D_B_21 0 5.038e-16
LD_B_21 D_B_21 D_B_22 6.5385e-10
BD_B_22 D_B_22 0 JJR area=1
CD_B_22 D_B_22 0 5.038e-16
LD_B_22 D_B_22 D_B_23 6.5385e-10
BD_B_23 D_B_23 0 JJR area=1
CD_B_23 D_B_23 0 5.038e-16
LD_B_23 D_B_23 D_B_24 6.5385e-10
BD_B_24 D_B_24 0 JJR area=1
CD_B_24 D_B_24 0 5.038e-16
LD_B_24 D_B_24 D_B_25 6.5385e-10
BD_B_25 D_B_25 0 JJR area=1
CD_B_25 D_B_25 0 5.038e-16
LD_B_25 D_B_25 D_B_26 6.5385e-10
BD_B_26 D_B_26 0 JJR area=1
CD_B_26 D_B_26 0 5.038e-16
LD_B_26 D_B_26 D_B_27 6.5385e-10
BD_B_27 D_B_27 0 JJR area=1
CD_B_27 D_B_27 0 5.038e-16
LD_B_27 D_B_27 D_B_28 6.5385e-10
BD_B_28 D_B_28 0 JJR area=1
CD_B_28 D_B_28 0 5.038e-16
LD_B_28 D_B_28 D_B_29 6.5385e-10
BD_B_29 D_B_29 0 JJR area=1
CD_B_29 D_B_29 0 5.038e-16
LD_B_29 D_B_29 D_B_30 6.5385e-10
BD_B_30 D_B_30 0 JJR area=1
CD_B_30 D_B_30 0 5.038e-16
LD_B_30 D_B_30 D_B_31 6.5385e-10
BD_B_31 D_B_31 0 JJR area=1
CD_B_31 D_B_31 0 5.038e-16
LD_B_31 D_B_31 D_B_32 6.5385e-10
BD_B_32 D_B_32 0 JJR area=1
CD_B_32 D_B_32 0 5.038e-16
LD_B_32 D_B_32 D_B_33 6.5385e-10
BD_B_33 D_B_33 0 JJR area=1
CD_B_33 D_B_33 0 5.038e-16
LD_B_33 D_B_33 D_B_34 6.5385e-10
BD_B_34 D_B_34 0 JJR area=1
CD_B_34 D_B_34 0 5.038e-16
LD_B_34 D_B_34 D_B_35 6.5385e-10
BD_B_35 D_B_35 0 JJR area=1
CD_B_35 D_B_35 0 5.038e-16
LD_B_35 D_B_35 D_B_36 6.5385e-10
BD_B_36 D_B_36 0 JJR area=1
CD_B_36 D_B_36 0 5.038e-16
LD_B_36 D_B_36 D_B_37 6.5385e-10
BD_B_37 D_B_37 0 JJR area=1
CD_B_37 D_B_37 0 5.038e-16
LD_B_37 D_B_37 D_B_38 6.5385e-10
BD_B_38 D_B_38 0 JJR area=1
CD_B_38 D_B_38 0 5.038e-16
LD_B_38 D_B_38 D_B_39 6.5385e-10
BD_B_39 D_B_39 0 JJR area=1
CD_B_39 D_B_39 0 5.038e-16
LD_B_39 D_B_39 D_B_40 6.5385e-10
BD_B_40 D_B_40 0 JJR area=1
CD_B_40 D_B_40 0 5.038e-16
LD_B_40 D_B_40 D_B_41 6.5385e-10
BD_B_41 D_B_41 0 JJR area=1
CD_B_41 D_B_41 0 5.038e-16
LD_B_41 D_B_41 D_B_42 6.5385e-10
BD_B_42 D_B_42 0 JJR area=1
CD_B_42 D_B_42 0 5.038e-16
LD_B_42 D_B_42 D_B_43 6.5385e-10
BD_B_43 D_B_43 0 JJR area=1
CD_B_43 D_B_43 0 5.038e-16
LD_B_43 D_B_43 D_B_44 6.5385e-10
BD_B_44 D_B_44 0 JJR area=1
CD_B_44 D_B_44 0 5.038e-16
LD_B_44 D_B_44 D_B_45 6.5385e-10
BD_B_45 D_B_45 0 JJR area=1
CD_B_45 D_B_45 0 5.038e-16
LD_B_45 D_B_45 D_B_46 6.5385e-10
BD_B_46 D_B_46 0 JJR area=1
CD_B_46 D_B_46 0 5.038e-16
LD_B_46 D_B_46 D_B_47 6.5385e-10
BD_B_47 D_B_47 0 JJR area=1
CD_B_47 D_B_47 0 5.038e-16
LD_B_47 D_B_47 D_B_48 6.5385e-10
BD_B_48 D_B_48 0 JJR area=1
CD_B_48 D_B_48 0 5.038e-16
LD_B_48 D_B_48 D_B_49 6.5385e-10
BD_B_49 D_B_49 0 JJR area=1
CD_B_49 D_B_49 0 5.038e-16
LD_B_49 D_B_49 D_B_50 6.5385e-10
BD_B_50 D_B_50 0 JJR area=1
CD_B_50 D_B_50 0 5.038e-16
LD_B_50 D_B_50 D_B_51 6.5385e-10
BD_B_51 D_B_51 0 JJR area=1
CD_B_51 D_B_51 0 5.038e-16
LD_B_51 D_B_51 D_B_52 6.5385e-10
BD_B_52 D_B_52 0 JJR area=1
CD_B_52 D_B_52 0 5.038e-16
LD_B_52 D_B_52 D_B_53 6.5385e-10
BD_B_53 D_B_53 0 JJR area=1
CD_B_53 D_B_53 0 5.038e-16
LD_B_53 D_B_53 D_B_54 6.5385e-10
BD_B_54 D_B_54 0 JJR area=1
CD_B_54 D_B_54 0 5.038e-16
LD_B_54 D_B_54 D_B_55 6.5385e-10
BD_B_55 D_B_55 0 JJR area=1
CD_B_55 D_B_55 0 5.038e-16
LD_B_55 D_B_55 D_B_56 6.5385e-10
BD_B_56 D_B_56 0 JJR area=1
CD_B_56 D_B_56 0 5.038e-16
LD_B_56 D_B_56 D_B_57 6.5385e-10
BD_B_57 D_B_57 0 JJR area=1
CD_B_57 D_B_57 0 5.038e-16
LD_B_57 D_B_57 D_B_58 6.5385e-10
BD_B_58 D_B_58 0 JJR area=1
CD_B_58 D_B_58 0 5.038e-16
LD_B_58 D_B_58 D_B_59 6.5385e-10
BD_B_59 D_B_59 0 JJR area=1
CD_B_59 D_B_59 0 5.038e-16
LD_B_59 D_B_59 D_B_60 6.5385e-10
BD_B_60 D_B_60 0 JJR area=1
CD_B_60 D_B_60 0 5.038e-16
LD_B_60 D_B_60 D_B_61 6.5385e-10
BD_B_61 D_B_61 0 JJR area=1
CD_B_61 D_B_61 0 5.038e-16
LD_B_61 D_B_61 D_B_62 6.5385e-10
BD_B_62 D_B_62 0 JJR area=1
CD_B_62 D_B_62 0 5.038e-16
LD_B_62 D_B_62 D_B_63 6.5385e-10
BD_B_63 D_B_63 0 JJR area=1
CD_B_63 D_B_63 0 5.038e-16
LD_B_63 D_B_63 D_B_64 6.5385e-10
BD_B_64 D_B_64 0 JJR area=1
CD_B_64 D_B_64 0 5.038e-16
LD_B_64 D_B_64 D_B_65 6.5385e-10
BD_B_65 D_B_65 0 JJR area=1
CD_B_65 D_B_65 0 5.038e-16
LD_B_65 D_B_65 D_B_66 6.5385e-10
BD_B_66 D_B_66 0 JJR area=1
CD_B_66 D_B_66 0 5.038e-16
LD_B_66 D_B_66 D_B_67 6.5385e-10
BD_B_67 D_B_67 0 JJR area=1
CD_B_67 D_B_67 0 5.038e-16
LD_B_67 D_B_67 D_B_68 6.5385e-10
BD_B_68 D_B_68 0 JJR area=1
CD_B_68 D_B_68 0 5.038e-16
LD_B_68 D_B_68 D_B_69 6.5385e-10
BD_B_69 D_B_69 0 JJR area=1
CD_B_69 D_B_69 0 5.038e-16
LD_B_69 D_B_69 D_B_70 6.5385e-10
BD_B_70 D_B_70 0 JJR area=1
CD_B_70 D_B_70 0 5.038e-16
LD_B_70 D_B_70 D_B_71 6.5385e-10
BD_B_71 D_B_71 0 JJR area=1
CD_B_71 D_B_71 0 5.038e-16
LD_B_71 D_B_71 D_B_72 6.5385e-10
BD_B_72 D_B_72 0 JJR area=1
CD_B_72 D_B_72 0 5.038e-16
LD_B_72 D_B_72 D_B_73 6.5385e-10
BD_B_73 D_B_73 0 JJR area=1
CD_B_73 D_B_73 0 5.038e-16
LD_B_73 D_B_73 D_B_74 6.5385e-10
BD_B_74 D_B_74 0 JJR area=1
CD_B_74 D_B_74 0 5.038e-16
LD_B_74 D_B_74 D_B_75 6.5385e-10
BD_B_75 D_B_75 0 JJR area=1
CD_B_75 D_B_75 0 5.038e-16
LD_B_75 D_B_75 D_B_76 6.5385e-10
BD_B_76 D_B_76 0 JJR area=1
CD_B_76 D_B_76 0 5.038e-16
LD_B_76 D_B_76 D_B_77 6.5385e-10
BD_B_77 D_B_77 0 JJR area=1
CD_B_77 D_B_77 0 5.038e-16
LD_B_77 D_B_77 D_B_78 6.5385e-10
BD_B_78 D_B_78 0 JJR area=1
CD_B_78 D_B_78 0 5.038e-16
LD_B_78 D_B_78 D_B_79 6.5385e-10
BD_B_79 D_B_79 0 JJR area=1
CD_B_79 D_B_79 0 5.038e-16
LD_B_79 D_B_79 D_B_80 6.5385e-10
BD_B_80 D_B_80 0 JJR area=1
CD_B_80 D_B_80 0 5.038e-16
LD_B_80 D_B_80 D_B_81 6.5385e-10
BD_B_81 D_B_81 0 JJR area=1
CD_B_81 D_B_81 0 5.038e-16
LD_B_81 D_B_81 D_B_82 6.5385e-10
BD_B_82 D_B_82 0 JJR area=1
CD_B_82 D_B_82 0 5.038e-16
LD_B_82 D_B_82 D_B_83 6.5385e-10
BD_B_83 D_B_83 0 JJR area=1
CD_B_83 D_B_83 0 5.038e-16
LD_B_83 D_B_83 D_B_84 6.5385e-10
BD_B_84 D_B_84 0 JJR area=1
CD_B_84 D_B_84 0 5.038e-16
LD_B_84 D_B_84 D_B_85 6.5385e-10
BD_B_85 D_B_85 0 JJR area=1
CD_B_85 D_B_85 0 5.038e-16
LD_B_85 D_B_85 D_B_86 6.5385e-10
BD_B_86 D_B_86 0 JJR area=1
CD_B_86 D_B_86 0 5.038e-16
LD_B_86 D_B_86 D_B_87 6.5385e-10
BD_B_87 D_B_87 0 JJR area=1
CD_B_87 D_B_87 0 5.038e-16
LD_B_87 D_B_87 D_B_88 6.5385e-10
BD_B_88 D_B_88 0 JJR area=1
CD_B_88 D_B_88 0 5.038e-16
LD_B_88 D_B_88 D_B_89 6.5385e-10
BD_B_89 D_B_89 0 JJR area=1
CD_B_89 D_B_89 0 5.038e-16
LD_B_89 D_B_89 D_B_90 6.5385e-10
BD_B_90 D_B_90 0 JJR area=1
CD_B_90 D_B_90 0 5.038e-16
LD_B_90 D_B_90 D_B_91 6.5385e-10
BD_B_91 D_B_91 0 JJR area=1
CD_B_91 D_B_91 0 5.038e-16
LD_B_91 D_B_91 D_B_92 6.5385e-10
BD_B_92 D_B_92 0 JJR area=1
CD_B_92 D_B_92 0 5.038e-16
LD_B_92 D_B_92 D_B_93 6.5385e-10
BD_B_93 D_B_93 0 JJR area=1
CD_B_93 D_B_93 0 5.038e-16
LD_B_93 D_B_93 D_B_94 6.5385e-10
BD_B_94 D_B_94 0 JJR area=1
CD_B_94 D_B_94 0 5.038e-16
LD_B_94 D_B_94 D_B_95 6.5385e-10
BD_B_95 D_B_95 0 JJR area=1
CD_B_95 D_B_95 0 5.038e-16
LD_B_95 D_B_95 D_B_96 6.5385e-10
BD_B_96 D_B_96 0 JJR area=1
CD_B_96 D_B_96 0 5.038e-16
LD_B_96 D_B_96 D_B_97 6.5385e-10
BD_B_97 D_B_97 0 JJR area=1
CD_B_97 D_B_97 0 5.038e-16
LD_B_97 D_B_97 D_B_98 6.5385e-10
BD_B_98 D_B_98 0 JJR area=1
CD_B_98 D_B_98 0 5.038e-16
LD_B_98 D_B_98 D_B_99 6.5385e-10
BD_B_99 D_B_99 0 JJR area=1
CD_B_99 D_B_99 0 5.038e-16
LD_B_99 D_B_99 D_B_100 6.5385e-10
BD_B_100 D_B_100 0 JJR area=1
CD_B_100 D_B_100 0 5.038e-16
LD_B_100 D_B_100 D_B_101 6.5385e-10
BD_B_101 D_B_101 0 JJR area=1
CD_B_101 D_B_101 0 5.038e-16
LD_B_101 D_B_101 D_B_102 6.5385e-10
BD_B_102 D_B_102 0 JJR area=1
CD_B_102 D_B_102 0 5.038e-16
LD_B_102 D_B_102 D_B_103 6.5385e-10
BD_B_103 D_B_103 0 JJR area=1
CD_B_103 D_B_103 0 5.038e-16
LD_B_103 D_B_103 D_B_104 6.5385e-10
BD_B_104 D_B_104 0 JJR area=1
CD_B_104 D_B_104 0 5.038e-16
LD_B_104 D_B_104 D_B_105 6.5385e-10
BD_B_105 D_B_105 0 JJR area=1
CD_B_105 D_B_105 0 5.038e-16
LD_B_105 D_B_105 D_B_106 6.5385e-10
BD_B_106 D_B_106 0 JJR area=1
CD_B_106 D_B_106 0 5.038e-16
LD_B_106 D_B_106 D_B_107 6.5385e-10
BD_B_107 D_B_107 0 JJR area=1
CD_B_107 D_B_107 0 5.038e-16
LD_B_107 D_B_107 D_B_108 6.5385e-10
BD_B_108 D_B_108 0 JJR area=1
CD_B_108 D_B_108 0 5.038e-16
LD_B_108 D_B_108 D_B_109 6.5385e-10
BD_B_109 D_B_109 0 JJR area=1
CD_B_109 D_B_109 0 5.038e-16
LD_B_109 D_B_109 D_B_110 6.5385e-10
BD_B_110 D_B_110 0 JJR area=1
CD_B_110 D_B_110 0 5.038e-16
LD_B_110 D_B_110 D_B_111 6.5384e-10
BD_B_111 D_B_111 SDB_111 JJR area=1
CD_B_111 D_B_111 0 5.037e-16
LD_B_111 D_B_111 D_B_112 6.5382e-10
BD_B_112 D_B_112 SDB_112 JJR area=1
CD_B_112 D_B_112 0 5.031e-16
LD_B_112 D_B_112 D_B_113 6.5377e-10
BD_B_113 D_B_113 SDB_113 JJR area=1
CD_B_113 D_B_113 0 5.018e-16
LD_B_113 D_B_113 D_B_114 6.5368e-10
BD_B_114 D_B_114 SDB_114 JJR area=1
CD_B_114 D_B_114 0 4.998e-16
LD_B_114 D_B_114 D_B_115 6.5356e-10
BD_B_115 D_B_115 SDB_115 JJR area=1
CD_B_115 D_B_115 0 4.973e-16
LD_B_115 D_B_115 D_B_116 6.534e-10
BD_B_116 D_B_116 SDB_116 JJR area=1
CD_B_116 D_B_116 0 4.941e-16
LD_B_116 D_B_116 D_B_117 6.5321e-10
BD_B_117 D_B_117 SDB_117 JJR area=1
CD_B_117 D_B_117 0 4.903e-16
LD_B_117 D_B_117 D_B_118 6.5299e-10
BD_B_118 D_B_118 SDB_118 JJR area=1
CD_B_118 D_B_118 0 4.86e-16
LD_B_118 D_B_118 D_B_119 6.5273e-10
BD_B_119 D_B_119 SDB_119 JJR area=1
CD_B_119 D_B_119 0 4.811e-16
LD_B_119 D_B_119 D_B_120 6.5245e-10
BD_B_120 D_B_120 SDB_120 JJR area=1
CD_B_120 D_B_120 0 4.757e-16
LD_B_120 D_B_120 D_B_121 6.5214e-10
BD_B_121 D_B_121 SDB_121 JJR area=1
CD_B_121 D_B_121 0 4.698e-16
LD_B_121 D_B_121 D_B_122 6.5181e-10
BD_B_122 D_B_122 SDB_122 JJR area=1
CD_B_122 D_B_122 0 4.635e-16
LD_B_122 D_B_122 D_B_123 6.5145e-10
BD_B_123 D_B_123 SDB_123 JJR area=1
CD_B_123 D_B_123 0 4.567e-16
LD_B_123 D_B_123 D_B_124 6.5107e-10
BD_B_124 D_B_124 SDB_124 JJR area=1
CD_B_124 D_B_124 0 4.496e-16
LD_B_124 D_B_124 D_B_125 6.5067e-10
BD_B_125 D_B_125 SDB_125 JJR area=1
CD_B_125 D_B_125 0 4.422e-16
LD_B_125 D_B_125 D_B_126 6.5026e-10
BD_B_126 D_B_126 SDB_126 JJR area=1
CD_B_126 D_B_126 0 4.346e-16
LD_B_126 D_B_126 D_B_127 6.4983e-10
BD_B_127 D_B_127 SDB_127 JJR area=1
CD_B_127 D_B_127 0 4.267e-16
LD_B_127 D_B_127 D_B_128 6.4939e-10
BD_B_128 D_B_128 SDB_128 JJR area=1
CD_B_128 D_B_128 0 4.186e-16
LD_B_128 D_B_128 D_B_129 6.4894e-10
BD_B_129 D_B_129 SDB_129 JJR area=1
CD_B_129 D_B_129 0 4.104e-16
LD_B_129 D_B_129 D_B_130 6.4849e-10
BD_B_130 D_B_130 SDB_130 JJR area=1
CD_B_130 D_B_130 0 4.021e-16
LD_B_130 D_B_130 D_B_131 6.4803e-10
BD_B_131 D_B_131 SDB_131 JJR area=1
CD_B_131 D_B_131 0 3.938e-16
LD_B_131 D_B_131 D_B_132 6.4758e-10
BD_B_132 D_B_132 SDB_132 JJR area=1
CD_B_132 D_B_132 0 3.855e-16
LD_B_132 D_B_132 D_B_133 6.4713e-10
BD_B_133 D_B_133 SDB_133 JJR area=1
CD_B_133 D_B_133 0 3.772e-16
LD_B_133 D_B_133 D_B_134 6.4668e-10
BD_B_134 D_B_134 SDB_134 JJR area=1
CD_B_134 D_B_134 0 3.692e-16
LD_B_134 D_B_134 D_B_135 6.4624e-10
BD_B_135 D_B_135 SDB_135 JJR area=1
CD_B_135 D_B_135 0 3.613e-16
LD_B_135 D_B_135 D_B_136 6.4581e-10
BD_B_136 D_B_136 SDB_136 JJR area=1
CD_B_136 D_B_136 0 3.536e-16
LD_B_136 D_B_136 D_B_137 6.454e-10
BD_B_137 D_B_137 SDB_137 JJR area=1
CD_B_137 D_B_137 0 3.462e-16
LD_B_137 D_B_137 D_B_138 6.45e-10
BD_B_138 D_B_138 SDB_138 JJR area=1
CD_B_138 D_B_138 0 3.391e-16
LD_B_138 D_B_138 D_B_139 6.4462e-10
BD_B_139 D_B_139 SDB_139 JJR area=1
CD_B_139 D_B_139 0 3.324e-16
LD_B_139 D_B_139 D_B_140 6.4426e-10
BD_B_140 D_B_140 SDB_140 JJR area=1
CD_B_140 D_B_140 0 3.26e-16
LD_B_140 D_B_140 D_B_141 6.4393e-10
BD_B_141 D_B_141 SDB_141 JJR area=1
CD_B_141 D_B_141 0 3.201e-16
LD_B_141 D_B_141 D_B_142 6.4362e-10
BD_B_142 D_B_142 SDB_142 JJR area=1
CD_B_142 D_B_142 0 3.147e-16
LD_B_142 D_B_142 D_B_143 6.4334e-10
BD_B_143 D_B_143 SDB_143 JJR area=1
CD_B_143 D_B_143 0 3.099e-16
LD_B_143 D_B_143 D_B_144 6.4308e-10
BD_B_144 D_B_144 SDB_144 JJR area=1
CD_B_144 D_B_144 0 3.055e-16
LD_B_144 D_B_144 D_B_145 6.4286e-10
BD_B_145 D_B_145 SDB_145 JJR area=1
CD_B_145 D_B_145 0 3.017e-16
LD_B_145 D_B_145 D_B_146 6.4267e-10
BD_B_146 D_B_146 SDB_146 JJR area=1
CD_B_146 D_B_146 0 2.986e-16
LD_B_146 D_B_146 D_B_147 6.4251e-10
BD_B_147 D_B_147 SDB_147 JJR area=1
CD_B_147 D_B_147 0 2.96e-16
LD_B_147 D_B_147 D_B_148 6.4239e-10
BD_B_148 D_B_148 SDB_148 JJR area=1
CD_B_148 D_B_148 0 2.941e-16
LD_B_148 D_B_148 D_B_149 6.423e-10
BD_B_149 D_B_149 SDB_149 JJR area=1
CD_B_149 D_B_149 0 2.928e-16
LD_B_149 D_B_149 D_B_150 6.4224e-10
BD_B_150 D_B_150 SDB_150 JJR area=1
CD_B_150 D_B_150 0 2.921e-16
LD_B_150 D_B_150 D_B_151 6.4222e-10
BD_B_151 D_B_151 SDB_151 JJR area=1
CD_B_151 D_B_151 0 2.92e-16
LD_B_151 D_B_151 D_B_152 6.4222e-10
BD_B_152 D_B_152 SDB_152 JJR area=1
CD_B_152 D_B_152 0 2.92e-16
LD_B_152 D_B_152 D_B_153 6.4222e-10
BD_B_153 D_B_153 SDB_153 JJR area=1
CD_B_153 D_B_153 0 2.92e-16
LD_B_153 D_B_153 D_B_154 6.4222e-10
BD_B_154 D_B_154 SDB_154 JJR area=1
CD_B_154 D_B_154 0 2.92e-16
LD_B_154 D_B_154 D_B_155 6.4222e-10
BD_B_155 D_B_155 SDB_155 JJR area=1
CD_B_155 D_B_155 0 2.92e-16
LD_B_155 D_B_155 D_B_156 6.4222e-10
BD_B_156 D_B_156 SDB_156 JJR area=1
CD_B_156 D_B_156 0 2.92e-16
LD_B_156 D_B_156 D_B_157 6.4222e-10
BD_B_157 D_B_157 SDB_157 JJR area=1
CD_B_157 D_B_157 0 2.92e-16
LD_B_157 D_B_157 D_B_158 6.4222e-10
BD_B_158 D_B_158 SDB_158 JJR area=1
CD_B_158 D_B_158 0 2.92e-16
LD_B_158 D_B_158 D_B_159 6.4222e-10
BD_B_159 D_B_159 SDB_159 JJR area=1
CD_B_159 D_B_159 0 2.92e-16
LD_B_159 D_B_159 D_B_160 6.4222e-10
BD_B_160 D_B_160 SDB_160 JJR area=1
CD_B_160 D_B_160 0 2.92e-16
LD_B_160 D_B_160 D_B_161 6.4222e-10
BD_B_161 D_B_161 SDB_161 JJR area=1
CD_B_161 D_B_161 0 2.92e-16
LD_B_161 D_B_161 D_B_162 6.4222e-10
BD_B_162 D_B_162 SDB_162 JJR area=1
CD_B_162 D_B_162 0 2.92e-16
LD_B_162 D_B_162 D_B_163 6.4222e-10
BD_B_163 D_B_163 SDB_163 JJR area=1
CD_B_163 D_B_163 0 2.92e-16
LD_B_163 D_B_163 D_B_164 6.4222e-10
BD_B_164 D_B_164 SDB_164 JJR area=1
CD_B_164 D_B_164 0 2.92e-16
LD_B_164 D_B_164 D_B_165 6.4222e-10
BD_B_165 D_B_165 SDB_165 JJR area=1
CD_B_165 D_B_165 0 2.92e-16
LD_B_165 D_B_165 D_B_166 6.4222e-10
BD_B_166 D_B_166 SDB_166 JJR area=1
CD_B_166 D_B_166 0 2.92e-16
LD_B_166 D_B_166 D_B_167 6.4222e-10
BD_B_167 D_B_167 SDB_167 JJR area=1
CD_B_167 D_B_167 0 2.92e-16
LD_B_167 D_B_167 D_B_168 6.4222e-10
BD_B_168 D_B_168 SDB_168 JJR area=1
CD_B_168 D_B_168 0 2.92e-16
LD_B_168 D_B_168 D_B_169 6.4222e-10
BD_B_169 D_B_169 SDB_169 JJR area=1
CD_B_169 D_B_169 0 2.92e-16
LD_B_169 D_B_169 D_B_170 6.4222e-10
BD_B_170 D_B_170 SDB_170 JJR area=1
CD_B_170 D_B_170 0 2.92e-16
LD_B_170 D_B_170 D_B_171 6.4222e-10
BD_B_171 D_B_171 SDB_171 JJR area=1
CD_B_171 D_B_171 0 2.92e-16
LD_B_171 D_B_171 D_B_172 6.4222e-10
BD_B_172 D_B_172 SDB_172 JJR area=1
CD_B_172 D_B_172 0 2.92e-16
LD_B_172 D_B_172 D_B_173 6.4222e-10
BD_B_173 D_B_173 SDB_173 JJR area=1
CD_B_173 D_B_173 0 2.92e-16
LD_B_173 D_B_173 D_B_174 6.4222e-10
BD_B_174 D_B_174 SDB_174 JJR area=1
CD_B_174 D_B_174 0 2.92e-16
LD_B_174 D_B_174 D_B_175 6.4222e-10
BD_B_175 D_B_175 SDB_175 JJR area=1
CD_B_175 D_B_175 0 2.92e-16
LD_B_175 D_B_175 D_B_176 6.4222e-10
BD_B_176 D_B_176 SDB_176 JJR area=1
CD_B_176 D_B_176 0 2.92e-16
LD_B_176 D_B_176 D_B_177 6.4222e-10
BD_B_177 D_B_177 SDB_177 JJR area=1
CD_B_177 D_B_177 0 2.92e-16
LD_B_177 D_B_177 D_B_178 6.4222e-10
BD_B_178 D_B_178 SDB_178 JJR area=1
CD_B_178 D_B_178 0 2.92e-16
LD_B_178 D_B_178 D_B_179 6.4222e-10
BD_B_179 D_B_179 SDB_179 JJR area=1
CD_B_179 D_B_179 0 2.92e-16
LD_B_179 D_B_179 D_B_180 6.4222e-10
BD_B_180 D_B_180 SDB_180 JJR area=1
CD_B_180 D_B_180 0 2.92e-16
LD_B_180 D_B_180 D_B_181 6.4222e-10
BD_B_181 D_B_181 SDB_181 JJR area=1
CD_B_181 D_B_181 0 2.92e-16
LD_B_181 D_B_181 D_B_182 6.4222e-10
BD_B_182 D_B_182 SDB_182 JJR area=1
CD_B_182 D_B_182 0 2.92e-16
LD_B_182 D_B_182 D_B_183 6.4222e-10
BD_B_183 D_B_183 SDB_183 JJR area=1
CD_B_183 D_B_183 0 2.92e-16
LD_B_183 D_B_183 D_B_184 6.4222e-10
BD_B_184 D_B_184 SDB_184 JJR area=1
CD_B_184 D_B_184 0 2.92e-16
LD_B_184 D_B_184 D_B_185 6.4222e-10
BD_B_185 D_B_185 SDB_185 JJR area=1
CD_B_185 D_B_185 0 2.92e-16
LD_B_185 D_B_185 D_B_186 6.4222e-10
BD_B_186 D_B_186 SDB_186 JJR area=1
CD_B_186 D_B_186 0 2.92e-16
LD_B_186 D_B_186 D_B_187 6.4222e-10
BD_B_187 D_B_187 SDB_187 JJR area=1
CD_B_187 D_B_187 0 2.92e-16
LD_B_187 D_B_187 D_B_188 6.4222e-10
BD_B_188 D_B_188 SDB_188 JJR area=1
CD_B_188 D_B_188 0 2.92e-16
LD_B_188 D_B_188 D_B_189 6.4222e-10
BD_B_189 D_B_189 SDB_189 JJR area=1
CD_B_189 D_B_189 0 2.92e-16
LD_B_189 D_B_189 D_B_190 6.4222e-10
BD_B_190 D_B_190 SDB_190 JJR area=1
CD_B_190 D_B_190 0 2.92e-16
LD_B_190 D_B_190 D_B_191 6.4222e-10
BD_B_191 D_B_191 SDB_191 JJR area=1
CD_B_191 D_B_191 0 2.92e-16
LD_B_191 D_B_191 D_B_192 6.4222e-10
BD_B_192 D_B_192 SDB_192 JJR area=1
CD_B_192 D_B_192 0 2.92e-16
LD_B_192 D_B_192 D_B_193 6.4222e-10
BD_B_193 D_B_193 SDB_193 JJR area=1
CD_B_193 D_B_193 0 2.92e-16
LD_B_193 D_B_193 D_B_194 6.4222e-10
BD_B_194 D_B_194 SDB_194 JJR area=1
CD_B_194 D_B_194 0 2.92e-16
LD_B_194 D_B_194 D_B_195 6.4222e-10
BD_B_195 D_B_195 SDB_195 JJR area=1
CD_B_195 D_B_195 0 2.92e-16
LD_B_195 D_B_195 D_B_196 6.4222e-10
BD_B_196 D_B_196 SDB_196 JJR area=1
CD_B_196 D_B_196 0 2.92e-16
LD_B_196 D_B_196 D_B_197 6.4222e-10
BD_B_197 D_B_197 SDB_197 JJR area=1
CD_B_197 D_B_197 0 2.92e-16
LD_B_197 D_B_197 D_B_198 6.4222e-10
BD_B_198 D_B_198 SDB_198 JJR area=1
CD_B_198 D_B_198 0 2.92e-16
LD_B_198 D_B_198 D_B_199 6.4222e-10
BD_B_199 D_B_199 SDB_199 JJR area=1
CD_B_199 D_B_199 0 2.92e-16
LD_B_199 D_B_199 D_B_200 6.4222e-10
BD_B_200 D_B_200 SDB_200 JJR area=1
CD_B_200 D_B_200 0 2.92e-16
LD_B_200 D_B_200 D_B_201 6.4222e-10
BD_B_201 D_B_201 SDB_201 JJR area=1
CD_B_201 D_B_201 0 2.92e-16
LD_B_201 D_B_201 D_B_202 6.4222e-10
BD_B_202 D_B_202 SDB_202 JJR area=1
CD_B_202 D_B_202 0 2.92e-16
LD_B_202 D_B_202 D_B_203 6.4222e-10
BD_B_203 D_B_203 SDB_203 JJR area=1
CD_B_203 D_B_203 0 2.92e-16
LD_B_203 D_B_203 D_B_204 6.4222e-10
BD_B_204 D_B_204 SDB_204 JJR area=1
CD_B_204 D_B_204 0 2.92e-16
LD_B_204 D_B_204 D_B_205 6.4222e-10
BD_B_205 D_B_205 SDB_205 JJR area=1
CD_B_205 D_B_205 0 2.92e-16
LD_B_205 D_B_205 D_B_206 6.4222e-10
BD_B_206 D_B_206 SDB_206 JJR area=1
CD_B_206 D_B_206 0 2.92e-16
LD_B_206 D_B_206 D_B_207 6.4222e-10
BD_B_207 D_B_207 SDB_207 JJR area=1
CD_B_207 D_B_207 0 2.92e-16
LD_B_207 D_B_207 D_B_208 6.4222e-10
BD_B_208 D_B_208 SDB_208 JJR area=1
CD_B_208 D_B_208 0 2.92e-16
LD_B_208 D_B_208 D_B_209 6.4222e-10
BD_B_209 D_B_209 SDB_209 JJR area=1
CD_B_209 D_B_209 0 2.92e-16
LD_B_209 D_B_209 D_B_210 6.4222e-10
BD_B_210 D_B_210 SDB_210 JJR area=1
CD_B_210 D_B_210 0 2.92e-16
LD_B_210 D_B_210 D_B_211 6.4222e-10
BD_B_211 D_B_211 SDB_211 JJR area=1
CD_B_211 D_B_211 0 2.92e-16
LD_B_211 D_B_211 D_B_212 6.4222e-10
BD_B_212 D_B_212 SDB_212 JJR area=1
CD_B_212 D_B_212 0 2.92e-16
LD_B_212 D_B_212 D_B_213 6.4222e-10
BD_B_213 D_B_213 SDB_213 JJR area=1
CD_B_213 D_B_213 0 2.92e-16
LD_B_213 D_B_213 D_B_214 6.4222e-10
BD_B_214 D_B_214 SDB_214 JJR area=1
CD_B_214 D_B_214 0 2.92e-16
LD_B_214 D_B_214 D_B_215 6.4222e-10
BD_B_215 D_B_215 SDB_215 JJR area=1
CD_B_215 D_B_215 0 2.92e-16
LD_B_215 D_B_215 D_B_216 6.4222e-10
BD_B_216 D_B_216 SDB_216 JJR area=1
CD_B_216 D_B_216 0 2.92e-16
LD_B_216 D_B_216 D_B_217 6.4222e-10
BD_B_217 D_B_217 SDB_217 JJR area=1
CD_B_217 D_B_217 0 2.92e-16
LD_B_217 D_B_217 D_B_218 6.4222e-10
BD_B_218 D_B_218 SDB_218 JJR area=1
CD_B_218 D_B_218 0 2.92e-16
LD_B_218 D_B_218 D_B_219 6.4222e-10
BD_B_219 D_B_219 SDB_219 JJR area=1
CD_B_219 D_B_219 0 2.92e-16
LD_B_219 D_B_219 D_B_220 6.4222e-10
BD_B_220 D_B_220 SDB_220 JJR area=1
CD_B_220 D_B_220 0 2.92e-16
LD_B_220 D_B_220 D_B_221 6.4222e-10
BD_B_221 D_B_221 SDB_221 JJR area=1
CD_B_221 D_B_221 0 2.92e-16
LD_B_221 D_B_221 D_B_222 6.4222e-10
BD_B_222 D_B_222 SDB_222 JJR area=1
CD_B_222 D_B_222 0 2.92e-16
LD_B_222 D_B_222 D_B_223 6.4222e-10
BD_B_223 D_B_223 SDB_223 JJR area=1
CD_B_223 D_B_223 0 2.92e-16
LD_B_223 D_B_223 D_B_224 6.4222e-10
BD_B_224 D_B_224 SDB_224 JJR area=1
CD_B_224 D_B_224 0 2.92e-16
LD_B_224 D_B_224 D_B_225 6.4222e-10
BD_B_225 D_B_225 SDB_225 JJR area=1
CD_B_225 D_B_225 0 2.92e-16
LD_B_225 D_B_225 D_B_226 6.4222e-10
BD_B_226 D_B_226 SDB_226 JJR area=1
CD_B_226 D_B_226 0 2.92e-16
LD_B_226 D_B_226 D_B_227 6.4222e-10
BD_B_227 D_B_227 SDB_227 JJR area=1
CD_B_227 D_B_227 0 2.92e-16
LD_B_227 D_B_227 D_B_228 6.4222e-10
BD_B_228 D_B_228 SDB_228 JJR area=1
CD_B_228 D_B_228 0 2.92e-16
LD_B_228 D_B_228 D_B_229 6.4222e-10
BD_B_229 D_B_229 SDB_229 JJR area=1
CD_B_229 D_B_229 0 2.92e-16
LD_B_229 D_B_229 D_B_230 6.4222e-10
BD_B_230 D_B_230 SDB_230 JJR area=1
CD_B_230 D_B_230 0 2.92e-16
LD_B_230 D_B_230 D_B_231 6.4222e-10
BD_B_231 D_B_231 SDB_231 JJR area=1
CD_B_231 D_B_231 0 2.92e-16
LD_B_231 D_B_231 D_B_232 6.4222e-10
BD_B_232 D_B_232 SDB_232 JJR area=1
CD_B_232 D_B_232 0 2.92e-16
LD_B_232 D_B_232 D_B_233 6.4222e-10
BD_B_233 D_B_233 SDB_233 JJR area=1
CD_B_233 D_B_233 0 2.92e-16
LD_B_233 D_B_233 D_B_234 6.4222e-10
BD_B_234 D_B_234 SDB_234 JJR area=1
CD_B_234 D_B_234 0 2.92e-16
LD_B_234 D_B_234 D_B_235 6.4222e-10
BD_B_235 D_B_235 SDB_235 JJR area=1
CD_B_235 D_B_235 0 2.92e-16
LD_B_235 D_B_235 D_B_236 6.4222e-10
BD_B_236 D_B_236 SDB_236 JJR area=1
CD_B_236 D_B_236 0 2.92e-16
LD_B_236 D_B_236 D_B_237 6.4222e-10
BD_B_237 D_B_237 SDB_237 JJR area=1
CD_B_237 D_B_237 0 2.92e-16
LD_B_237 D_B_237 D_B_238 6.4222e-10
BD_B_238 D_B_238 SDB_238 JJR area=1
CD_B_238 D_B_238 0 2.92e-16
LD_B_238 D_B_238 D_B_239 6.4222e-10
BD_B_239 D_B_239 SDB_239 JJR area=1
CD_B_239 D_B_239 0 2.92e-16
LD_B_239 D_B_239 D_B_240 6.4222e-10
BD_B_240 D_B_240 SDB_240 JJR area=1
CD_B_240 D_B_240 0 2.92e-16
LD_B_240 D_B_240 D_B_241 6.4222e-10
BD_B_241 D_B_241 SDB_241 JJR area=1
CD_B_241 D_B_241 0 2.92e-16
LD_B_241 D_B_241 D_B_242 6.4222e-10
BD_B_242 D_B_242 SDB_242 JJR area=1
CD_B_242 D_B_242 0 2.92e-16
LD_B_242 D_B_242 D_B_243 6.4222e-10
BD_B_243 D_B_243 SDB_243 JJR area=1
CD_B_243 D_B_243 0 2.92e-16
LD_B_243 D_B_243 D_B_244 6.4222e-10
BD_B_244 D_B_244 SDB_244 JJR area=1
CD_B_244 D_B_244 0 2.92e-16
LD_B_244 D_B_244 D_B_245 6.4222e-10
BD_B_245 D_B_245 SDB_245 JJR area=1
CD_B_245 D_B_245 0 2.92e-16
LD_B_245 D_B_245 D_B_246 6.4222e-10
BD_B_246 D_B_246 SDB_246 JJR area=1
CD_B_246 D_B_246 0 2.92e-16
LD_B_246 D_B_246 D_B_247 6.4222e-10
BD_B_247 D_B_247 SDB_247 JJR area=1
CD_B_247 D_B_247 0 2.92e-16
LD_B_247 D_B_247 D_B_248 6.4222e-10
BD_B_248 D_B_248 SDB_248 JJR area=1
CD_B_248 D_B_248 0 2.92e-16
LD_B_248 D_B_248 D_B_249 6.4222e-10
BD_B_249 D_B_249 SDB_249 JJR area=1
CD_B_249 D_B_249 0 2.92e-16
LD_B_249 D_B_249 D_B_250 6.4222e-10
BD_B_250 D_B_250 SDB_250 JJR area=1
CD_B_250 D_B_250 0 2.92e-16
LD_B_250 D_B_250 D_B_251 6.4222e-10
BD_B_251 D_B_251 SDB_251 JJR area=1
CD_B_251 D_B_251 0 2.921e-16
LD_B_251 D_B_251 D_B_252 6.4224e-10
BD_B_252 D_B_252 SDB_252 JJR area=1
CD_B_252 D_B_252 0 2.928e-16
LD_B_252 D_B_252 D_B_253 6.423e-10
BD_B_253 D_B_253 SDB_253 JJR area=1
CD_B_253 D_B_253 0 2.941e-16
LD_B_253 D_B_253 D_B_254 6.4239e-10
BD_B_254 D_B_254 SDB_254 JJR area=1
CD_B_254 D_B_254 0 2.96e-16
LD_B_254 D_B_254 D_B_255 6.4251e-10
BD_B_255 D_B_255 SDB_255 JJR area=1
CD_B_255 D_B_255 0 2.986e-16
LD_B_255 D_B_255 D_B_256 6.4267e-10
BD_B_256 D_B_256 SDB_256 JJR area=1
CD_B_256 D_B_256 0 3.017e-16
LD_B_256 D_B_256 D_B_257 6.4286e-10
BD_B_257 D_B_257 SDB_257 JJR area=1
CD_B_257 D_B_257 0 3.055e-16
LD_B_257 D_B_257 D_B_258 6.4308e-10
BD_B_258 D_B_258 SDB_258 JJR area=1
CD_B_258 D_B_258 0 3.099e-16
LD_B_258 D_B_258 D_B_259 6.4334e-10
BD_B_259 D_B_259 SDB_259 JJR area=1
CD_B_259 D_B_259 0 3.147e-16
LD_B_259 D_B_259 D_B_260 6.4362e-10
BD_B_260 D_B_260 SDB_260 JJR area=1
CD_B_260 D_B_260 0 3.201e-16
LD_B_260 D_B_260 D_B_261 6.4393e-10
BD_B_261 D_B_261 SDB_261 JJR area=1
CD_B_261 D_B_261 0 3.26e-16
LD_B_261 D_B_261 D_B_262 6.4426e-10
BD_B_262 D_B_262 SDB_262 JJR area=1
CD_B_262 D_B_262 0 3.324e-16
LD_B_262 D_B_262 D_B_263 6.4462e-10
BD_B_263 D_B_263 SDB_263 JJR area=1
CD_B_263 D_B_263 0 3.391e-16
LD_B_263 D_B_263 D_B_264 6.45e-10
BD_B_264 D_B_264 SDB_264 JJR area=1
CD_B_264 D_B_264 0 3.462e-16
LD_B_264 D_B_264 D_B_265 6.454e-10
BD_B_265 D_B_265 SDB_265 JJR area=1
CD_B_265 D_B_265 0 3.536e-16
LD_B_265 D_B_265 D_B_266 6.4581e-10
BD_B_266 D_B_266 SDB_266 JJR area=1
CD_B_266 D_B_266 0 3.613e-16
LD_B_266 D_B_266 D_B_267 6.4624e-10
BD_B_267 D_B_267 SDB_267 JJR area=1
CD_B_267 D_B_267 0 3.692e-16
LD_B_267 D_B_267 D_B_268 6.4668e-10
BD_B_268 D_B_268 SDB_268 JJR area=1
CD_B_268 D_B_268 0 3.772e-16
LD_B_268 D_B_268 D_B_269 6.4713e-10
BD_B_269 D_B_269 SDB_269 JJR area=1
CD_B_269 D_B_269 0 3.855e-16
LD_B_269 D_B_269 D_B_270 6.4758e-10
BD_B_270 D_B_270 SDB_270 JJR area=1
CD_B_270 D_B_270 0 3.938e-16
LD_B_270 D_B_270 D_B_271 6.4803e-10
BD_B_271 D_B_271 SDB_271 JJR area=1
CD_B_271 D_B_271 0 4.021e-16
LD_B_271 D_B_271 D_B_272 6.4849e-10
BD_B_272 D_B_272 SDB_272 JJR area=1
CD_B_272 D_B_272 0 4.104e-16
LD_B_272 D_B_272 D_B_273 6.4894e-10
BD_B_273 D_B_273 SDB_273 JJR area=1
CD_B_273 D_B_273 0 4.186e-16
LD_B_273 D_B_273 D_B_274 6.4939e-10
BD_B_274 D_B_274 SDB_274 JJR area=1
CD_B_274 D_B_274 0 4.267e-16
LD_B_274 D_B_274 D_B_275 6.4983e-10
BD_B_275 D_B_275 SDB_275 JJR area=1
CD_B_275 D_B_275 0 4.346e-16
LD_B_275 D_B_275 D_B_276 6.5026e-10
BD_B_276 D_B_276 SDB_276 JJR area=1
CD_B_276 D_B_276 0 4.422e-16
LD_B_276 D_B_276 D_B_277 6.5067e-10
BD_B_277 D_B_277 SDB_277 JJR area=1
CD_B_277 D_B_277 0 4.496e-16
LD_B_277 D_B_277 D_B_278 6.5107e-10
BD_B_278 D_B_278 SDB_278 JJR area=1
CD_B_278 D_B_278 0 4.567e-16
LD_B_278 D_B_278 D_B_279 6.5145e-10
BD_B_279 D_B_279 SDB_279 JJR area=1
CD_B_279 D_B_279 0 4.635e-16
LD_B_279 D_B_279 D_B_280 6.5181e-10
BD_B_280 D_B_280 SDB_280 JJR area=1
CD_B_280 D_B_280 0 4.698e-16
LD_B_280 D_B_280 D_B_281 6.5214e-10
BD_B_281 D_B_281 SDB_281 JJR area=1
CD_B_281 D_B_281 0 4.757e-16
LD_B_281 D_B_281 D_B_282 6.5245e-10
BD_B_282 D_B_282 SDB_282 JJR area=1
CD_B_282 D_B_282 0 4.811e-16
LD_B_282 D_B_282 D_B_283 6.5273e-10
BD_B_283 D_B_283 SDB_283 JJR area=1
CD_B_283 D_B_283 0 4.86e-16
LD_B_283 D_B_283 D_B_284 6.5299e-10
BD_B_284 D_B_284 SDB_284 JJR area=1
CD_B_284 D_B_284 0 4.903e-16
LD_B_284 D_B_284 D_B_285 6.5321e-10
BD_B_285 D_B_285 SDB_285 JJR area=1
CD_B_285 D_B_285 0 4.941e-16
LD_B_285 D_B_285 D_B_286 6.534e-10
BD_B_286 D_B_286 SDB_286 JJR area=1
CD_B_286 D_B_286 0 4.973e-16
LD_B_286 D_B_286 D_B_287 6.5356e-10
BD_B_287 D_B_287 SDB_287 JJR area=1
CD_B_287 D_B_287 0 4.998e-16
LD_B_287 D_B_287 D_B_288 6.5368e-10
BD_B_288 D_B_288 SDB_288 JJR area=1
CD_B_288 D_B_288 0 5.018e-16
LD_B_288 D_B_288 D_B_289 6.5377e-10
BD_B_289 D_B_289 SDB_289 JJR area=1
CD_B_289 D_B_289 0 5.031e-16
LD_B_289 D_B_289 D_B_290 6.5382e-10
BD_B_290 D_B_290 SDB_290 JJR area=1
CD_B_290 D_B_290 0 5.037e-16
LD_B_290 D_B_290 D_B_291 6.5384e-10
BD_B_291 D_B_291 0 JJR area=1
CD_B_291 D_B_291 0 5.038e-16
LD_B_291 D_B_291 D_B_292 6.5385e-10
BD_B_292 D_B_292 0 JJR area=1
CD_B_292 D_B_292 0 5.038e-16
LD_B_292 D_B_292 D_B_293 6.5385e-10
BD_B_293 D_B_293 0 JJR area=1
CD_B_293 D_B_293 0 5.038e-16
LD_B_293 D_B_293 D_B_294 6.5385e-10
BD_B_294 D_B_294 0 JJR area=1
CD_B_294 D_B_294 0 5.038e-16
LD_B_294 D_B_294 D_B_295 6.5385e-10
BD_B_295 D_B_295 0 JJR area=1
CD_B_295 D_B_295 0 5.038e-16
LD_B_295 D_B_295 D_B_296 6.5385e-10
BD_B_296 D_B_296 0 JJR area=1
CD_B_296 D_B_296 0 5.038e-16
LD_B_296 D_B_296 D_B_297 6.5385e-10
BD_B_297 D_B_297 0 JJR area=1
CD_B_297 D_B_297 0 5.038e-16
LD_B_297 D_B_297 D_B_298 6.5385e-10
BD_B_298 D_B_298 0 JJR area=1
CD_B_298 D_B_298 0 5.038e-16
LD_B_298 D_B_298 D_B_299 6.5385e-10
BD_B_299 D_B_299 0 JJR area=1
CD_B_299 D_B_299 0 5.038e-16
LD_B_299 D_B_299 D_B_300 6.5385e-10
BD_B_300 D_B_300 0 JJR area=1
CD_B_300 D_B_300 0 5.038e-16
LD_B_300 D_B_300 D_B_301 6.5385e-10
BD_B_301 D_B_301 0 JJR area=1
CD_B_301 D_B_301 0 5.038e-16
LD_B_301 D_B_301 D_B_302 6.5385e-10
BD_B_302 D_B_302 0 JJR area=1
CD_B_302 D_B_302 0 5.038e-16
LD_B_302 D_B_302 D_B_303 6.5385e-10
BD_B_303 D_B_303 0 JJR area=1
CD_B_303 D_B_303 0 5.038e-16
LD_B_303 D_B_303 D_B_304 6.5385e-10
BD_B_304 D_B_304 0 JJR area=1
CD_B_304 D_B_304 0 5.038e-16
LD_B_304 D_B_304 D_B_305 6.5385e-10
BD_B_305 D_B_305 0 JJR area=1
CD_B_305 D_B_305 0 5.038e-16
LD_B_305 D_B_305 D_B_306 6.5385e-10
BD_B_306 D_B_306 0 JJR area=1
CD_B_306 D_B_306 0 5.038e-16
LD_B_306 D_B_306 D_B_307 6.5385e-10
BD_B_307 D_B_307 0 JJR area=1
CD_B_307 D_B_307 0 5.038e-16
LD_B_307 D_B_307 D_B_308 6.5385e-10
BD_B_308 D_B_308 0 JJR area=1
CD_B_308 D_B_308 0 5.038e-16
LD_B_308 D_B_308 D_B_309 6.5385e-10
BD_B_309 D_B_309 0 JJR area=1
CD_B_309 D_B_309 0 5.038e-16
LD_B_309 D_B_309 D_B_310 6.5385e-10
BD_B_310 D_B_310 0 JJR area=1
CD_B_310 D_B_310 0 5.038e-16
LD_B_310 D_B_310 D_B_311 6.5385e-10
BD_B_311 D_B_311 0 JJR area=1
CD_B_311 D_B_311 0 5.038e-16
LD_B_311 D_B_311 D_B_312 6.5385e-10
BD_B_312 D_B_312 0 JJR area=1
CD_B_312 D_B_312 0 5.038e-16
LD_B_312 D_B_312 D_B_313 6.5385e-10
BD_B_313 D_B_313 0 JJR area=1
CD_B_313 D_B_313 0 5.038e-16
LD_B_313 D_B_313 D_B_314 6.5385e-10
BD_B_314 D_B_314 0 JJR area=1
CD_B_314 D_B_314 0 5.038e-16
LD_B_314 D_B_314 D_B_315 6.5385e-10
BD_B_315 D_B_315 0 JJR area=1
CD_B_315 D_B_315 0 5.038e-16
LD_B_315 D_B_315 D_B_316 6.5385e-10
BD_B_316 D_B_316 0 JJR area=1
CD_B_316 D_B_316 0 5.038e-16
LD_B_316 D_B_316 D_B_317 6.5385e-10
BD_B_317 D_B_317 0 JJR area=1
CD_B_317 D_B_317 0 5.038e-16
LD_B_317 D_B_317 D_B_318 6.5385e-10
BD_B_318 D_B_318 0 JJR area=1
CD_B_318 D_B_318 0 5.038e-16
LD_B_318 D_B_318 D_B_319 6.5385e-10
BD_B_319 D_B_319 0 JJR area=1
CD_B_319 D_B_319 0 5.038e-16
LD_B_319 D_B_319 D_B_320 6.5385e-10
BD_B_320 D_B_320 0 JJR area=1
CD_B_320 D_B_320 0 5.038e-16
LD_B_320 D_B_320 D_B_321 6.5385e-10
BD_B_321 D_B_321 0 JJR area=1
CD_B_321 D_B_321 0 5.038e-16
LD_B_321 D_B_321 D_B_322 6.5385e-10
BD_B_322 D_B_322 0 JJR area=1
CD_B_322 D_B_322 0 5.038e-16
LD_B_322 D_B_322 D_B_323 6.5385e-10
BD_B_323 D_B_323 0 JJR area=1
CD_B_323 D_B_323 0 5.038e-16
LD_B_323 D_B_323 D_B_324 6.5385e-10
BD_B_324 D_B_324 0 JJR area=1
CD_B_324 D_B_324 0 5.038e-16
LD_B_324 D_B_324 D_B_325 6.5385e-10
BD_B_325 D_B_325 0 JJR area=1
CD_B_325 D_B_325 0 5.038e-16
LD_B_325 D_B_325 D_B_326 6.5385e-10
BD_B_326 D_B_326 0 JJR area=1
CD_B_326 D_B_326 0 5.038e-16
LD_B_326 D_B_326 D_B_327 6.5385e-10
BD_B_327 D_B_327 0 JJR area=1
CD_B_327 D_B_327 0 5.038e-16
LD_B_327 D_B_327 D_B_328 6.5385e-10
BD_B_328 D_B_328 0 JJR area=1
CD_B_328 D_B_328 0 5.038e-16
LD_B_328 D_B_328 D_B_329 6.5385e-10
BD_B_329 D_B_329 0 JJR area=1
CD_B_329 D_B_329 0 5.038e-16
LD_B_329 D_B_329 D_B_330 6.5385e-10
BD_B_330 D_B_330 0 JJR area=1
CD_B_330 D_B_330 0 5.038e-16
LD_B_330 D_B_330 D_B_331 6.5385e-10
BD_B_331 D_B_331 0 JJR area=1
CD_B_331 D_B_331 0 5.038e-16
LD_B_331 D_B_331 D_B_332 6.5385e-10
BD_B_332 D_B_332 0 JJR area=1
CD_B_332 D_B_332 0 5.038e-16
LD_B_332 D_B_332 D_B_333 6.5385e-10
BD_B_333 D_B_333 0 JJR area=1
CD_B_333 D_B_333 0 5.038e-16
LD_B_333 D_B_333 D_B_334 6.5385e-10
BD_B_334 D_B_334 0 JJR area=1
CD_B_334 D_B_334 0 5.038e-16
LD_B_334 D_B_334 D_B_335 6.5385e-10
BD_B_335 D_B_335 0 JJR area=1
CD_B_335 D_B_335 0 5.038e-16
LD_B_335 D_B_335 D_B_336 6.5385e-10
BD_B_336 D_B_336 0 JJR area=1
CD_B_336 D_B_336 0 5.038e-16
LD_B_336 D_B_336 D_B_337 6.5385e-10
BD_B_337 D_B_337 0 JJR area=1
CD_B_337 D_B_337 0 5.038e-16
LD_B_337 D_B_337 D_B_338 6.5385e-10
BD_B_338 D_B_338 0 JJR area=1
CD_B_338 D_B_338 0 5.038e-16
LD_B_338 D_B_338 D_B_339 6.5385e-10
BD_B_339 D_B_339 0 JJR area=1
CD_B_339 D_B_339 0 5.038e-16
LD_B_339 D_B_339 D_B_340 6.5385e-10
BD_B_340 D_B_340 0 JJR area=1
CD_B_340 D_B_340 0 5.038e-16
LD_B_340 D_B_340 D_B_341 6.5385e-10
BD_B_341 D_B_341 0 JJR area=1
CD_B_341 D_B_341 0 5.038e-16
LD_B_341 D_B_341 D_B_342 6.5385e-10
BD_B_342 D_B_342 0 JJR area=1
CD_B_342 D_B_342 0 5.038e-16
LD_B_342 D_B_342 D_B_343 6.5385e-10
BD_B_343 D_B_343 0 JJR area=1
CD_B_343 D_B_343 0 5.038e-16
LD_B_343 D_B_343 D_B_344 6.5385e-10
BD_B_344 D_B_344 0 JJR area=1
CD_B_344 D_B_344 0 5.038e-16
LD_B_344 D_B_344 D_B_345 6.5385e-10
BD_B_345 D_B_345 0 JJR area=1
CD_B_345 D_B_345 0 5.038e-16
LD_B_345 D_B_345 D_B_346 6.5385e-10
BD_B_346 D_B_346 0 JJR area=1
CD_B_346 D_B_346 0 5.038e-16
LD_B_346 D_B_346 D_B_347 6.5385e-10
BD_B_347 D_B_347 0 JJR area=1
CD_B_347 D_B_347 0 5.038e-16
LD_B_347 D_B_347 D_B_348 6.5385e-10
BD_B_348 D_B_348 0 JJR area=1
CD_B_348 D_B_348 0 5.038e-16
LD_B_348 D_B_348 D_B_349 6.5385e-10
BD_B_349 D_B_349 0 JJR area=1
CD_B_349 D_B_349 0 5.038e-16
LD_B_349 D_B_349 D_B_350 6.5385e-10
BD_B_350 D_B_350 0 JJR area=1
CD_B_350 D_B_350 0 5.038e-16
LD_B_350 D_B_350 D_B_351 6.5385e-10
BD_B_351 D_B_351 0 JJR area=1
CD_B_351 D_B_351 0 5.038e-16
LD_B_351 D_B_351 D_B_352 6.5385e-10
BD_B_352 D_B_352 0 JJR area=1
CD_B_352 D_B_352 0 5.038e-16
LD_B_352 D_B_352 D_B_353 6.5385e-10
BD_B_353 D_B_353 0 JJR area=1
CD_B_353 D_B_353 0 5.038e-16
LD_B_353 D_B_353 D_B_354 6.5385e-10
BD_B_354 D_B_354 0 JJR area=1
CD_B_354 D_B_354 0 5.038e-16
LD_B_354 D_B_354 D_B_355 6.5385e-10
BD_B_355 D_B_355 0 JJR area=1
CD_B_355 D_B_355 0 5.038e-16
LD_B_355 D_B_355 D_B_356 6.5385e-10
BD_B_356 D_B_356 0 JJR area=1
CD_B_356 D_B_356 0 5.038e-16
LD_B_356 D_B_356 D_B_357 6.5385e-10
BD_B_357 D_B_357 0 JJR area=1
CD_B_357 D_B_357 0 5.038e-16
LD_B_357 D_B_357 D_B_358 6.5385e-10
BD_B_358 D_B_358 0 JJR area=1
CD_B_358 D_B_358 0 5.038e-16
LD_B_358 D_B_358 D_B_359 6.5385e-10
BD_B_359 D_B_359 0 JJR area=1
CD_B_359 D_B_359 0 5.038e-16
LD_B_359 D_B_359 D_B_360 6.5385e-10
BD_B_360 D_B_360 0 JJR area=1
CD_B_360 D_B_360 0 5.038e-16
LD_B_360 D_B_360 D_B_361 6.5385e-10
BD_B_361 D_B_361 0 JJR area=1
CD_B_361 D_B_361 0 5.038e-16
LSDA_111 SDA_111 SDA_112 4.481e-15
CCDA_111 D_A_111 A0_111 8.164e-20
LSDA_112 SDA_112 SDA_113 4.0287e-14
CCDA_112 D_A_112 A0_112 7.34e-19
LSDA_113 SDA_113 SDA_114 1.1168e-13
CCDA_113 D_A_113 A0_113 2.035e-18
LSDA_114 SDA_114 SDA_115 2.1822e-13
CCDA_114 D_A_114 A0_114 3.976e-18
LSDA_115 SDA_115 SDA_116 3.5924e-13
CCDA_115 D_A_115 A0_115 6.545e-18
LSDA_116 SDA_116 SDA_117 5.3389e-13
CCDA_116 D_A_116 A0_116 9.727e-18
LSDA_117 SDA_117 SDA_118 7.4107e-13
CCDA_117 D_A_117 A0_117 1.35e-17
LSDA_118 SDA_118 SDA_119 9.7953e-13
CCDA_118 D_A_118 A0_118 1.785e-17
LSDA_119 SDA_119 SDA_120 1.2478e-12
CCDA_119 D_A_119 A0_119 2.273e-17
LSDA_120 SDA_120 SDA_121 1.5442e-12
CCDA_120 D_A_120 A0_120 2.813e-17
LSDA_121 SDA_121 SDA_122 1.8669e-12
CCDA_121 D_A_121 A0_121 3.401e-17
LSDA_122 SDA_122 SDA_123 2.2139e-12
CCDA_122 D_A_122 A0_122 4.033e-17
LSDA_123 SDA_123 SDA_124 2.5831e-12
CCDA_123 D_A_123 A0_123 4.706e-17
LSDA_124 SDA_124 SDA_125 2.9722e-12
CCDA_124 D_A_124 A0_124 5.415e-17
LSDA_125 SDA_125 SDA_126 3.3788e-12
CCDA_125 D_A_125 A0_125 6.156e-17
LSDA_126 SDA_126 SDA_127 3.8005e-12
CCDA_126 D_A_126 A0_126 6.924e-17
LSDA_127 SDA_127 SDA_128 4.2345e-12
CCDA_127 D_A_127 A0_127 7.715e-17
LSDA_128 SDA_128 SDA_129 4.6783e-12
CCDA_128 D_A_128 A0_128 8.523e-17
LSDA_129 SDA_129 SDA_130 5.129e-12
CCDA_129 D_A_129 A0_129 9.344e-17
LSDA_130 SDA_130 SDA_131 5.584e-12
CCDA_130 D_A_130 A0_130 1.017e-16
LSDA_131 SDA_131 SDA_132 6.0404e-12
CCDA_131 D_A_131 A0_131 1.1e-16
LSDA_132 SDA_132 SDA_133 6.4953e-12
CCDA_132 D_A_132 A0_132 1.183e-16
LSDA_133 SDA_133 SDA_134 6.9461e-12
CCDA_133 D_A_133 A0_133 1.265e-16
LSDA_134 SDA_134 SDA_135 7.3898e-12
CCDA_134 D_A_134 A0_134 1.346e-16
LSDA_135 SDA_135 SDA_136 7.8239e-12
CCDA_135 D_A_135 A0_135 1.425e-16
LSDA_136 SDA_136 SDA_137 8.2455e-12
CCDA_136 D_A_136 A0_136 1.502e-16
LSDA_137 SDA_137 SDA_138 8.6521e-12
CCDA_137 D_A_137 A0_137 1.576e-16
LSDA_138 SDA_138 SDA_139 9.0412e-12
CCDA_138 D_A_138 A0_138 1.647e-16
LSDA_139 SDA_139 SDA_140 9.4104e-12
CCDA_139 D_A_139 A0_139 1.714e-16
LSDA_140 SDA_140 SDA_141 9.7575e-12
CCDA_140 D_A_140 A0_140 1.778e-16
LSDA_141 SDA_141 SDA_142 1.008e-11
CCDA_141 D_A_141 A0_141 1.836e-16
LSDA_142 SDA_142 SDA_143 1.0377e-11
CCDA_142 D_A_142 A0_142 1.89e-16
LSDA_143 SDA_143 SDA_144 1.0645e-11
CCDA_143 D_A_143 A0_143 1.939e-16
LSDA_144 SDA_144 SDA_145 1.0883e-11
CCDA_144 D_A_144 A0_144 1.983e-16
LSDA_145 SDA_145 SDA_146 1.109e-11
CCDA_145 D_A_145 A0_145 2.021e-16
LSDA_146 SDA_146 SDA_147 1.1265e-11
CCDA_146 D_A_146 A0_146 2.052e-16
LSDA_147 SDA_147 SDA_148 1.1406e-11
CCDA_147 D_A_147 A0_147 2.078e-16
LSDA_148 SDA_148 SDA_149 1.1513e-11
CCDA_148 D_A_148 A0_148 2.097e-16
LSDA_149 SDA_149 SDA_150 1.1584e-11
CCDA_149 D_A_149 A0_149 2.11e-16
LSDA_150 SDA_150 SDA_151 1.162e-11
CCDA_150 D_A_150 A0_150 2.117e-16
LSDA_151 SDA_151 SDA_152 1.1624e-11
CCDA_151 D_A_151 A0_151 2.118e-16
LSDA_152 SDA_152 SDA_153 1.1624e-11
CCDA_152 D_A_152 A0_152 2.118e-16
LSDA_153 SDA_153 SDA_154 1.1624e-11
CCDA_153 D_A_153 A0_153 2.118e-16
LSDA_154 SDA_154 SDA_155 1.1624e-11
CCDA_154 D_A_154 A0_154 2.118e-16
LSDA_155 SDA_155 SDA_156 1.1624e-11
CCDA_155 D_A_155 A0_155 2.118e-16
LSDA_156 SDA_156 SDA_157 1.1624e-11
CCDA_156 D_A_156 A0_156 2.118e-16
LSDA_157 SDA_157 SDA_158 1.1624e-11
CCDA_157 D_A_157 A0_157 2.118e-16
LSDA_158 SDA_158 SDA_159 1.1624e-11
CCDA_158 D_A_158 A0_158 2.118e-16
LSDA_159 SDA_159 SDA_160 1.1624e-11
CCDA_159 D_A_159 A0_159 2.118e-16
LSDA_160 SDA_160 SDA_161 1.1624e-11
CCDA_160 D_A_160 A0_160 2.118e-16
LSDA_161 SDA_161 SDA_162 1.1624e-11
CCDA_161 D_A_161 A0_161 2.118e-16
LSDA_162 SDA_162 SDA_163 1.1624e-11
CCDA_162 D_A_162 A0_162 2.118e-16
LSDA_163 SDA_163 SDA_164 1.1624e-11
CCDA_163 D_A_163 A0_163 2.118e-16
LSDA_164 SDA_164 SDA_165 1.1624e-11
CCDA_164 D_A_164 A0_164 2.118e-16
LSDA_165 SDA_165 SDA_166 1.1624e-11
CCDA_165 D_A_165 A0_165 2.118e-16
LSDA_166 SDA_166 SDA_167 1.1624e-11
CCDA_166 D_A_166 A0_166 2.118e-16
LSDA_167 SDA_167 SDA_168 1.1624e-11
CCDA_167 D_A_167 A0_167 2.118e-16
LSDA_168 SDA_168 SDA_169 1.1624e-11
CCDA_168 D_A_168 A0_168 2.118e-16
LSDA_169 SDA_169 SDA_170 1.1624e-11
CCDA_169 D_A_169 A0_169 2.118e-16
LSDA_170 SDA_170 SDA_171 1.1624e-11
CCDA_170 D_A_170 A0_170 2.118e-16
LSDA_171 SDA_171 SDA_172 1.1624e-11
CCDA_171 D_A_171 A0_171 2.118e-16
LSDA_172 SDA_172 SDA_173 1.1624e-11
CCDA_172 D_A_172 A0_172 2.118e-16
LSDA_173 SDA_173 SDA_174 1.1624e-11
CCDA_173 D_A_173 A0_173 2.118e-16
LSDA_174 SDA_174 SDA_175 1.1624e-11
CCDA_174 D_A_174 A0_174 2.118e-16
LSDA_175 SDA_175 SDA_176 1.1624e-11
CCDA_175 D_A_175 A0_175 2.118e-16
LSDA_176 SDA_176 SDA_177 1.1624e-11
CCDA_176 D_A_176 A0_176 2.118e-16
LSDA_177 SDA_177 SDA_178 1.1624e-11
CCDA_177 D_A_177 A0_177 2.118e-16
LSDA_178 SDA_178 SDA_179 1.1624e-11
CCDA_178 D_A_178 A0_178 2.118e-16
LSDA_179 SDA_179 SDA_180 1.1624e-11
CCDA_179 D_A_179 A0_179 2.118e-16
LSDA_180 SDA_180 SDA_181 1.1624e-11
CCDA_180 D_A_180 A0_180 2.118e-16
LSDA_181 SDA_181 SDA_182 1.1624e-11
CCDA_181 D_A_181 A0_181 2.118e-16
LSDA_182 SDA_182 SDA_183 1.1624e-11
CCDA_182 D_A_182 A0_182 2.118e-16
LSDA_183 SDA_183 SDA_184 1.1624e-11
CCDA_183 D_A_183 A0_183 2.118e-16
LSDA_184 SDA_184 SDA_185 1.1624e-11
CCDA_184 D_A_184 A0_184 2.118e-16
LSDA_185 SDA_185 SDA_186 1.1624e-11
CCDA_185 D_A_185 A0_185 2.118e-16
LSDA_186 SDA_186 SDA_187 1.1624e-11
CCDA_186 D_A_186 A0_186 2.118e-16
LSDA_187 SDA_187 SDA_188 1.1624e-11
CCDA_187 D_A_187 A0_187 2.118e-16
LSDA_188 SDA_188 SDA_189 1.1624e-11
CCDA_188 D_A_188 A0_188 2.118e-16
LSDA_189 SDA_189 SDA_190 1.1624e-11
CCDA_189 D_A_189 A0_189 2.118e-16
LSDA_190 SDA_190 SDA_191 1.1624e-11
CCDA_190 D_A_190 A0_190 2.118e-16
LSDA_191 SDA_191 SDA_192 1.1624e-11
CCDA_191 D_A_191 A0_191 2.118e-16
LSDA_192 SDA_192 SDA_193 1.1624e-11
CCDA_192 D_A_192 A0_192 2.118e-16
LSDA_193 SDA_193 SDA_194 1.1624e-11
CCDA_193 D_A_193 A0_193 2.118e-16
LSDA_194 SDA_194 SDA_195 1.1624e-11
CCDA_194 D_A_194 A0_194 2.118e-16
LSDA_195 SDA_195 SDA_196 1.1624e-11
CCDA_195 D_A_195 A0_195 2.118e-16
LSDA_196 SDA_196 SDA_197 1.1624e-11
CCDA_196 D_A_196 A0_196 2.118e-16
LSDA_197 SDA_197 SDA_198 1.1624e-11
CCDA_197 D_A_197 A0_197 2.118e-16
LSDA_198 SDA_198 SDA_199 1.1624e-11
CCDA_198 D_A_198 A0_198 2.118e-16
LSDA_199 SDA_199 SDA_200 1.1624e-11
CCDA_199 D_A_199 A0_199 2.118e-16
LSDA_200 SDA_200 SDA_201 1.1624e-11
CCDA_200 D_A_200 A0_200 2.118e-16
LSDA_201 SDA_201 SDA_202 1.1624e-11
CCDA_201 D_A_201 A0_201 2.118e-16
LSDA_202 SDA_202 SDA_203 1.1624e-11
CCDA_202 D_A_202 A0_202 2.118e-16
LSDA_203 SDA_203 SDA_204 1.1624e-11
CCDA_203 D_A_203 A0_203 2.118e-16
LSDA_204 SDA_204 SDA_205 1.1624e-11
CCDA_204 D_A_204 A0_204 2.118e-16
LSDA_205 SDA_205 SDA_206 1.1624e-11
CCDA_205 D_A_205 A0_205 2.118e-16
LSDA_206 SDA_206 SDA_207 1.1624e-11
CCDA_206 D_A_206 A0_206 2.118e-16
LSDA_207 SDA_207 SDA_208 1.1624e-11
CCDA_207 D_A_207 A0_207 2.118e-16
LSDA_208 SDA_208 SDA_209 1.1624e-11
CCDA_208 D_A_208 A0_208 2.118e-16
LSDA_209 SDA_209 SDA_210 1.1624e-11
CCDA_209 D_A_209 A0_209 2.118e-16
LSDA_210 SDA_210 SDA_211 1.1624e-11
CCDA_210 D_A_210 A0_210 2.118e-16
LSDA_211 SDA_211 SDA_212 1.1624e-11
CCDA_211 D_A_211 A0_211 2.118e-16
LSDA_212 SDA_212 SDA_213 1.1624e-11
CCDA_212 D_A_212 A0_212 2.118e-16
LSDA_213 SDA_213 SDA_214 1.1624e-11
CCDA_213 D_A_213 A0_213 2.118e-16
LSDA_214 SDA_214 SDA_215 1.1624e-11
CCDA_214 D_A_214 A0_214 2.118e-16
LSDA_215 SDA_215 SDA_216 1.1624e-11
CCDA_215 D_A_215 A0_215 2.118e-16
LSDA_216 SDA_216 SDA_217 1.1624e-11
CCDA_216 D_A_216 A0_216 2.118e-16
LSDA_217 SDA_217 SDA_218 1.1624e-11
CCDA_217 D_A_217 A0_217 2.118e-16
LSDA_218 SDA_218 SDA_219 1.1624e-11
CCDA_218 D_A_218 A0_218 2.118e-16
LSDA_219 SDA_219 SDA_220 1.1624e-11
CCDA_219 D_A_219 A0_219 2.118e-16
LSDA_220 SDA_220 SDA_221 1.1624e-11
CCDA_220 D_A_220 A0_220 2.118e-16
LSDA_221 SDA_221 SDA_222 1.1624e-11
CCDA_221 D_A_221 A0_221 2.118e-16
LSDA_222 SDA_222 SDA_223 1.1624e-11
CCDA_222 D_A_222 A0_222 2.118e-16
LSDA_223 SDA_223 SDA_224 1.1624e-11
CCDA_223 D_A_223 A0_223 2.118e-16
LSDA_224 SDA_224 SDA_225 1.1624e-11
CCDA_224 D_A_224 A0_224 2.118e-16
LSDA_225 SDA_225 SDA_226 1.1624e-11
CCDA_225 D_A_225 A0_225 2.118e-16
LSDA_226 SDA_226 SDA_227 1.1624e-11
CCDA_226 D_A_226 A0_226 2.118e-16
LSDA_227 SDA_227 SDA_228 1.1624e-11
CCDA_227 D_A_227 A0_227 2.118e-16
LSDA_228 SDA_228 SDA_229 1.1624e-11
CCDA_228 D_A_228 A0_228 2.118e-16
LSDA_229 SDA_229 SDA_230 1.1624e-11
CCDA_229 D_A_229 A0_229 2.118e-16
LSDA_230 SDA_230 SDA_231 1.1624e-11
CCDA_230 D_A_230 A0_230 2.118e-16
LSDA_231 SDA_231 SDA_232 1.1624e-11
CCDA_231 D_A_231 A0_231 2.118e-16
LSDA_232 SDA_232 SDA_233 1.1624e-11
CCDA_232 D_A_232 A0_232 2.118e-16
LSDA_233 SDA_233 SDA_234 1.1624e-11
CCDA_233 D_A_233 A0_233 2.118e-16
LSDA_234 SDA_234 SDA_235 1.1624e-11
CCDA_234 D_A_234 A0_234 2.118e-16
LSDA_235 SDA_235 SDA_236 1.1624e-11
CCDA_235 D_A_235 A0_235 2.118e-16
LSDA_236 SDA_236 SDA_237 1.1624e-11
CCDA_236 D_A_236 A0_236 2.118e-16
LSDA_237 SDA_237 SDA_238 1.1624e-11
CCDA_237 D_A_237 A0_237 2.118e-16
LSDA_238 SDA_238 SDA_239 1.1624e-11
CCDA_238 D_A_238 A0_238 2.118e-16
LSDA_239 SDA_239 SDA_240 1.1624e-11
CCDA_239 D_A_239 A0_239 2.118e-16
LSDA_240 SDA_240 SDA_241 1.1624e-11
CCDA_240 D_A_240 A0_240 2.118e-16
LSDA_241 SDA_241 SDA_242 1.1624e-11
CCDA_241 D_A_241 A0_241 2.118e-16
LSDA_242 SDA_242 SDA_243 1.1624e-11
CCDA_242 D_A_242 A0_242 2.118e-16
LSDA_243 SDA_243 SDA_244 1.1624e-11
CCDA_243 D_A_243 A0_243 2.118e-16
LSDA_244 SDA_244 SDA_245 1.1624e-11
CCDA_244 D_A_244 A0_244 2.118e-16
LSDA_245 SDA_245 SDA_246 1.1624e-11
CCDA_245 D_A_245 A0_245 2.118e-16
LSDA_246 SDA_246 SDA_247 1.1624e-11
CCDA_246 D_A_246 A0_246 2.118e-16
LSDA_247 SDA_247 SDA_248 1.1624e-11
CCDA_247 D_A_247 A0_247 2.118e-16
LSDA_248 SDA_248 SDA_249 1.1624e-11
CCDA_248 D_A_248 A0_248 2.118e-16
LSDA_249 SDA_249 SDA_250 1.1624e-11
CCDA_249 D_A_249 A0_249 2.118e-16
LSDA_250 SDA_250 SDA_251 1.1624e-11
CCDA_250 D_A_250 A0_250 2.118e-16
LSDA_251 SDA_251 SDA_252 1.162e-11
CCDA_251 D_A_251 A0_251 2.117e-16
LSDA_252 SDA_252 SDA_253 1.1584e-11
CCDA_252 D_A_252 A0_252 2.11e-16
LSDA_253 SDA_253 SDA_254 1.1513e-11
CCDA_253 D_A_253 A0_253 2.097e-16
LSDA_254 SDA_254 SDA_255 1.1406e-11
CCDA_254 D_A_254 A0_254 2.078e-16
LSDA_255 SDA_255 SDA_256 1.1265e-11
CCDA_255 D_A_255 A0_255 2.052e-16
LSDA_256 SDA_256 SDA_257 1.109e-11
CCDA_256 D_A_256 A0_256 2.021e-16
LSDA_257 SDA_257 SDA_258 1.0883e-11
CCDA_257 D_A_257 A0_257 1.983e-16
LSDA_258 SDA_258 SDA_259 1.0645e-11
CCDA_258 D_A_258 A0_258 1.939e-16
LSDA_259 SDA_259 SDA_260 1.0377e-11
CCDA_259 D_A_259 A0_259 1.89e-16
LSDA_260 SDA_260 SDA_261 1.008e-11
CCDA_260 D_A_260 A0_260 1.836e-16
LSDA_261 SDA_261 SDA_262 9.7575e-12
CCDA_261 D_A_261 A0_261 1.778e-16
LSDA_262 SDA_262 SDA_263 9.4104e-12
CCDA_262 D_A_262 A0_262 1.714e-16
LSDA_263 SDA_263 SDA_264 9.0412e-12
CCDA_263 D_A_263 A0_263 1.647e-16
LSDA_264 SDA_264 SDA_265 8.6521e-12
CCDA_264 D_A_264 A0_264 1.576e-16
LSDA_265 SDA_265 SDA_266 8.2455e-12
CCDA_265 D_A_265 A0_265 1.502e-16
LSDA_266 SDA_266 SDA_267 7.8239e-12
CCDA_266 D_A_266 A0_266 1.425e-16
LSDA_267 SDA_267 SDA_268 7.3898e-12
CCDA_267 D_A_267 A0_267 1.346e-16
LSDA_268 SDA_268 SDA_269 6.9461e-12
CCDA_268 D_A_268 A0_268 1.265e-16
LSDA_269 SDA_269 SDA_270 6.4953e-12
CCDA_269 D_A_269 A0_269 1.183e-16
LSDA_270 SDA_270 SDA_271 6.0404e-12
CCDA_270 D_A_270 A0_270 1.1e-16
LSDA_271 SDA_271 SDA_272 5.584e-12
CCDA_271 D_A_271 A0_271 1.017e-16
LSDA_272 SDA_272 SDA_273 5.129e-12
CCDA_272 D_A_272 A0_272 9.344e-17
LSDA_273 SDA_273 SDA_274 4.6783e-12
CCDA_273 D_A_273 A0_273 8.523e-17
LSDA_274 SDA_274 SDA_275 4.2345e-12
CCDA_274 D_A_274 A0_274 7.715e-17
LSDA_275 SDA_275 SDA_276 3.8005e-12
CCDA_275 D_A_275 A0_275 6.924e-17
LSDA_276 SDA_276 SDA_277 3.3788e-12
CCDA_276 D_A_276 A0_276 6.156e-17
LSDA_277 SDA_277 SDA_278 2.9722e-12
CCDA_277 D_A_277 A0_277 5.415e-17
LSDA_278 SDA_278 SDA_279 2.5831e-12
CCDA_278 D_A_278 A0_278 4.706e-17
LSDA_279 SDA_279 SDA_280 2.2139e-12
CCDA_279 D_A_279 A0_279 4.033e-17
LSDA_280 SDA_280 SDA_281 1.8669e-12
CCDA_280 D_A_280 A0_280 3.401e-17
LSDA_281 SDA_281 SDA_282 1.5442e-12
CCDA_281 D_A_281 A0_281 2.813e-17
LSDA_282 SDA_282 SDA_283 1.2478e-12
CCDA_282 D_A_282 A0_282 2.273e-17
LSDA_283 SDA_283 SDA_284 9.7953e-13
CCDA_283 D_A_283 A0_283 1.785e-17
LSDA_284 SDA_284 SDA_285 7.4107e-13
CCDA_284 D_A_284 A0_284 1.35e-17
LSDA_285 SDA_285 SDA_286 5.3389e-13
CCDA_285 D_A_285 A0_285 9.727e-18
LSDA_286 SDA_286 SDA_287 3.5924e-13
CCDA_286 D_A_286 A0_286 6.545e-18
LSDA_287 SDA_287 SDA_288 2.1822e-13
CCDA_287 D_A_287 A0_287 3.976e-18
LSDA_288 SDA_288 SDA_289 1.1168e-13
CCDA_288 D_A_288 A0_288 2.035e-18
LSDA_289 SDA_289 SDA_290 4.0287e-14
CCDA_289 D_A_289 A0_289 7.34e-19
LSDA_290 SDA_290 0 4.481e-15
CCDA_290 D_A_290 A0_290 8.164e-20
LSDA_entry SDA_111 0 1p
LSG_111 SG_111 SG_112 4.481e-15
CCG_111 A1_111 B1_111 8.164e-20
LSG_112 SG_112 SG_113 4.0287e-14
CCG_112 A1_112 B1_112 7.34e-19
LSG_113 SG_113 SG_114 1.1168e-13
CCG_113 A1_113 B1_113 2.035e-18
LSG_114 SG_114 SG_115 2.1822e-13
CCG_114 A1_114 B1_114 3.976e-18
LSG_115 SG_115 SG_116 3.5924e-13
CCG_115 A1_115 B1_115 6.545e-18
LSG_116 SG_116 SG_117 5.3389e-13
CCG_116 A1_116 B1_116 9.727e-18
LSG_117 SG_117 SG_118 7.4107e-13
CCG_117 A1_117 B1_117 1.35e-17
LSG_118 SG_118 SG_119 9.7953e-13
CCG_118 A1_118 B1_118 1.785e-17
LSG_119 SG_119 SG_120 1.2478e-12
CCG_119 A1_119 B1_119 2.273e-17
LSG_120 SG_120 SG_121 1.5442e-12
CCG_120 A1_120 B1_120 2.813e-17
LSG_121 SG_121 SG_122 1.8669e-12
CCG_121 A1_121 B1_121 3.401e-17
LSG_122 SG_122 SG_123 2.2139e-12
CCG_122 A1_122 B1_122 4.033e-17
LSG_123 SG_123 SG_124 2.5831e-12
CCG_123 A1_123 B1_123 4.706e-17
LSG_124 SG_124 SG_125 2.9722e-12
CCG_124 A1_124 B1_124 5.415e-17
LSG_125 SG_125 SG_126 3.3788e-12
CCG_125 A1_125 B1_125 6.156e-17
LSG_126 SG_126 SG_127 3.8005e-12
CCG_126 A1_126 B1_126 6.924e-17
LSG_127 SG_127 SG_128 4.2345e-12
CCG_127 A1_127 B1_127 7.715e-17
LSG_128 SG_128 SG_129 4.6783e-12
CCG_128 A1_128 B1_128 8.523e-17
LSG_129 SG_129 SG_130 5.129e-12
CCG_129 A1_129 B1_129 9.344e-17
LSG_130 SG_130 SG_131 5.584e-12
CCG_130 A1_130 B1_130 1.017e-16
LSG_131 SG_131 SG_132 6.0404e-12
CCG_131 A1_131 B1_131 1.1e-16
LSG_132 SG_132 SG_133 6.4953e-12
CCG_132 A1_132 B1_132 1.183e-16
LSG_133 SG_133 SG_134 6.9461e-12
CCG_133 A1_133 B1_133 1.265e-16
LSG_134 SG_134 SG_135 7.3898e-12
CCG_134 A1_134 B1_134 1.346e-16
LSG_135 SG_135 SG_136 7.8239e-12
CCG_135 A1_135 B1_135 1.425e-16
LSG_136 SG_136 SG_137 8.2455e-12
CCG_136 A1_136 B1_136 1.502e-16
LSG_137 SG_137 SG_138 8.6521e-12
CCG_137 A1_137 B1_137 1.576e-16
LSG_138 SG_138 SG_139 9.0412e-12
CCG_138 A1_138 B1_138 1.647e-16
LSG_139 SG_139 SG_140 9.4104e-12
CCG_139 A1_139 B1_139 1.714e-16
LSG_140 SG_140 SG_141 9.7575e-12
CCG_140 A1_140 B1_140 1.778e-16
LSG_141 SG_141 SG_142 1.008e-11
CCG_141 A1_141 B1_141 1.836e-16
LSG_142 SG_142 SG_143 1.0377e-11
CCG_142 A1_142 B1_142 1.89e-16
LSG_143 SG_143 SG_144 1.0645e-11
CCG_143 A1_143 B1_143 1.939e-16
LSG_144 SG_144 SG_145 1.0883e-11
CCG_144 A1_144 B1_144 1.983e-16
LSG_145 SG_145 SG_146 1.109e-11
CCG_145 A1_145 B1_145 2.021e-16
LSG_146 SG_146 SG_147 1.1265e-11
CCG_146 A1_146 B1_146 2.052e-16
LSG_147 SG_147 SG_148 1.1406e-11
CCG_147 A1_147 B1_147 2.078e-16
LSG_148 SG_148 SG_149 1.1513e-11
CCG_148 A1_148 B1_148 2.097e-16
LSG_149 SG_149 SG_150 1.1584e-11
CCG_149 A1_149 B1_149 2.11e-16
LSG_150 SG_150 SG_151 1.162e-11
CCG_150 A1_150 B1_150 2.117e-16
LSG_151 SG_151 SG_152 1.1624e-11
CCG_151 A1_151 B1_151 2.118e-16
LSG_152 SG_152 SG_153 1.1624e-11
CCG_152 A1_152 B1_152 2.118e-16
LSG_153 SG_153 SG_154 1.1624e-11
CCG_153 A1_153 B1_153 2.118e-16
LSG_154 SG_154 SG_155 1.1624e-11
CCG_154 A1_154 B1_154 2.118e-16
LSG_155 SG_155 SG_156 1.1624e-11
CCG_155 A1_155 B1_155 2.118e-16
LSG_156 SG_156 SG_157 1.1624e-11
CCG_156 A1_156 B1_156 2.118e-16
LSG_157 SG_157 SG_158 1.1624e-11
CCG_157 A1_157 B1_157 2.118e-16
LSG_158 SG_158 SG_159 1.1624e-11
CCG_158 A1_158 B1_158 2.118e-16
LSG_159 SG_159 SG_160 1.1624e-11
CCG_159 A1_159 B1_159 2.118e-16
LSG_160 SG_160 SG_161 1.1624e-11
CCG_160 A1_160 B1_160 2.118e-16
LSG_161 SG_161 SG_162 1.1624e-11
CCG_161 A1_161 B1_161 2.118e-16
LSG_162 SG_162 SG_163 1.1624e-11
CCG_162 A1_162 B1_162 2.118e-16
LSG_163 SG_163 SG_164 1.1624e-11
CCG_163 A1_163 B1_163 2.118e-16
LSG_164 SG_164 SG_165 1.1624e-11
CCG_164 A1_164 B1_164 2.118e-16
LSG_165 SG_165 SG_166 1.1624e-11
CCG_165 A1_165 B1_165 2.118e-16
LSG_166 SG_166 SG_167 1.1624e-11
CCG_166 A1_166 B1_166 2.118e-16
LSG_167 SG_167 SG_168 1.1624e-11
CCG_167 A1_167 B1_167 2.118e-16
LSG_168 SG_168 SG_169 1.1624e-11
CCG_168 A1_168 B1_168 2.118e-16
LSG_169 SG_169 SG_170 1.1624e-11
CCG_169 A1_169 B1_169 2.118e-16
LSG_170 SG_170 SG_171 1.1624e-11
CCG_170 A1_170 B1_170 2.118e-16
LSG_171 SG_171 SG_172 1.1624e-11
CCG_171 A1_171 B1_171 2.118e-16
LSG_172 SG_172 SG_173 1.1624e-11
CCG_172 A1_172 B1_172 2.118e-16
LSG_173 SG_173 SG_174 1.1624e-11
CCG_173 A1_173 B1_173 2.118e-16
LSG_174 SG_174 SG_175 1.1624e-11
CCG_174 A1_174 B1_174 2.118e-16
LSG_175 SG_175 SG_176 1.1624e-11
CCG_175 A1_175 B1_175 2.118e-16
LSG_176 SG_176 SG_177 1.1624e-11
CCG_176 A1_176 B1_176 2.118e-16
LSG_177 SG_177 SG_178 1.1624e-11
CCG_177 A1_177 B1_177 2.118e-16
LSG_178 SG_178 SG_179 1.1624e-11
CCG_178 A1_178 B1_178 2.118e-16
LSG_179 SG_179 SG_180 1.1624e-11
CCG_179 A1_179 B1_179 2.118e-16
LSG_180 SG_180 SG_181 1.1624e-11
CCG_180 A1_180 B1_180 2.118e-16
LSG_181 SG_181 SG_182 1.1624e-11
CCG_181 A1_181 B1_181 2.118e-16
LSG_182 SG_182 SG_183 1.1624e-11
CCG_182 A1_182 B1_182 2.118e-16
LSG_183 SG_183 SG_184 1.1624e-11
CCG_183 A1_183 B1_183 2.118e-16
LSG_184 SG_184 SG_185 1.1624e-11
CCG_184 A1_184 B1_184 2.118e-16
LSG_185 SG_185 SG_186 1.1624e-11
CCG_185 A1_185 B1_185 2.118e-16
LSG_186 SG_186 SG_187 1.1624e-11
CCG_186 A1_186 B1_186 2.118e-16
LSG_187 SG_187 SG_188 1.1624e-11
CCG_187 A1_187 B1_187 2.118e-16
LSG_188 SG_188 SG_189 1.1624e-11
CCG_188 A1_188 B1_188 2.118e-16
LSG_189 SG_189 SG_190 1.1624e-11
CCG_189 A1_189 B1_189 2.118e-16
LSG_190 SG_190 SG_191 1.1624e-11
CCG_190 A1_190 B1_190 2.118e-16
LSG_191 SG_191 SG_192 1.1624e-11
CCG_191 A1_191 B1_191 2.118e-16
LSG_192 SG_192 SG_193 1.1624e-11
CCG_192 A1_192 B1_192 2.118e-16
LSG_193 SG_193 SG_194 1.1624e-11
CCG_193 A1_193 B1_193 2.118e-16
LSG_194 SG_194 SG_195 1.1624e-11
CCG_194 A1_194 B1_194 2.118e-16
LSG_195 SG_195 SG_196 1.1624e-11
CCG_195 A1_195 B1_195 2.118e-16
LSG_196 SG_196 SG_197 1.1624e-11
CCG_196 A1_196 B1_196 2.118e-16
LSG_197 SG_197 SG_198 1.1624e-11
CCG_197 A1_197 B1_197 2.118e-16
LSG_198 SG_198 SG_199 1.1624e-11
CCG_198 A1_198 B1_198 2.118e-16
LSG_199 SG_199 SG_200 1.1624e-11
CCG_199 A1_199 B1_199 2.118e-16
LSG_200 SG_200 SG_201 1.1624e-11
CCG_200 A1_200 B1_200 2.118e-16
LSG_201 SG_201 SG_202 1.1624e-11
CCG_201 A1_201 B1_201 2.118e-16
LSG_202 SG_202 SG_203 1.1624e-11
CCG_202 A1_202 B1_202 2.118e-16
LSG_203 SG_203 SG_204 1.1624e-11
CCG_203 A1_203 B1_203 2.118e-16
LSG_204 SG_204 SG_205 1.1624e-11
CCG_204 A1_204 B1_204 2.118e-16
LSG_205 SG_205 SG_206 1.1624e-11
CCG_205 A1_205 B1_205 2.118e-16
LSG_206 SG_206 SG_207 1.1624e-11
CCG_206 A1_206 B1_206 2.118e-16
LSG_207 SG_207 SG_208 1.1624e-11
CCG_207 A1_207 B1_207 2.118e-16
LSG_208 SG_208 SG_209 1.1624e-11
CCG_208 A1_208 B1_208 2.118e-16
LSG_209 SG_209 SG_210 1.1624e-11
CCG_209 A1_209 B1_209 2.118e-16
LSG_210 SG_210 SG_211 1.1624e-11
CCG_210 A1_210 B1_210 2.118e-16
LSG_211 SG_211 SG_212 1.1624e-11
CCG_211 A1_211 B1_211 2.118e-16
LSG_212 SG_212 SG_213 1.1624e-11
CCG_212 A1_212 B1_212 2.118e-16
LSG_213 SG_213 SG_214 1.1624e-11
CCG_213 A1_213 B1_213 2.118e-16
LSG_214 SG_214 SG_215 1.1624e-11
CCG_214 A1_214 B1_214 2.118e-16
LSG_215 SG_215 SG_216 1.1624e-11
CCG_215 A1_215 B1_215 2.118e-16
LSG_216 SG_216 SG_217 1.1624e-11
CCG_216 A1_216 B1_216 2.118e-16
LSG_217 SG_217 SG_218 1.1624e-11
CCG_217 A1_217 B1_217 2.118e-16
LSG_218 SG_218 SG_219 1.1624e-11
CCG_218 A1_218 B1_218 2.118e-16
LSG_219 SG_219 SG_220 1.1624e-11
CCG_219 A1_219 B1_219 2.118e-16
LSG_220 SG_220 SG_221 1.1624e-11
CCG_220 A1_220 B1_220 2.118e-16
LSG_221 SG_221 SG_222 1.1624e-11
CCG_221 A1_221 B1_221 2.118e-16
LSG_222 SG_222 SG_223 1.1624e-11
CCG_222 A1_222 B1_222 2.118e-16
LSG_223 SG_223 SG_224 1.1624e-11
CCG_223 A1_223 B1_223 2.118e-16
LSG_224 SG_224 SG_225 1.1624e-11
CCG_224 A1_224 B1_224 2.118e-16
LSG_225 SG_225 SG_226 1.1624e-11
CCG_225 A1_225 B1_225 2.118e-16
LSG_226 SG_226 SG_227 1.1624e-11
CCG_226 A1_226 B1_226 2.118e-16
LSG_227 SG_227 SG_228 1.1624e-11
CCG_227 A1_227 B1_227 2.118e-16
LSG_228 SG_228 SG_229 1.1624e-11
CCG_228 A1_228 B1_228 2.118e-16
LSG_229 SG_229 SG_230 1.1624e-11
CCG_229 A1_229 B1_229 2.118e-16
LSG_230 SG_230 SG_231 1.1624e-11
CCG_230 A1_230 B1_230 2.118e-16
LSG_231 SG_231 SG_232 1.1624e-11
CCG_231 A1_231 B1_231 2.118e-16
LSG_232 SG_232 SG_233 1.1624e-11
CCG_232 A1_232 B1_232 2.118e-16
LSG_233 SG_233 SG_234 1.1624e-11
CCG_233 A1_233 B1_233 2.118e-16
LSG_234 SG_234 SG_235 1.1624e-11
CCG_234 A1_234 B1_234 2.118e-16
LSG_235 SG_235 SG_236 1.1624e-11
CCG_235 A1_235 B1_235 2.118e-16
LSG_236 SG_236 SG_237 1.1624e-11
CCG_236 A1_236 B1_236 2.118e-16
LSG_237 SG_237 SG_238 1.1624e-11
CCG_237 A1_237 B1_237 2.118e-16
LSG_238 SG_238 SG_239 1.1624e-11
CCG_238 A1_238 B1_238 2.118e-16
LSG_239 SG_239 SG_240 1.1624e-11
CCG_239 A1_239 B1_239 2.118e-16
LSG_240 SG_240 SG_241 1.1624e-11
CCG_240 A1_240 B1_240 2.118e-16
LSG_241 SG_241 SG_242 1.1624e-11
CCG_241 A1_241 B1_241 2.118e-16
LSG_242 SG_242 SG_243 1.1624e-11
CCG_242 A1_242 B1_242 2.118e-16
LSG_243 SG_243 SG_244 1.1624e-11
CCG_243 A1_243 B1_243 2.118e-16
LSG_244 SG_244 SG_245 1.1624e-11
CCG_244 A1_244 B1_244 2.118e-16
LSG_245 SG_245 SG_246 1.1624e-11
CCG_245 A1_245 B1_245 2.118e-16
LSG_246 SG_246 SG_247 1.1624e-11
CCG_246 A1_246 B1_246 2.118e-16
LSG_247 SG_247 SG_248 1.1624e-11
CCG_247 A1_247 B1_247 2.118e-16
LSG_248 SG_248 SG_249 1.1624e-11
CCG_248 A1_248 B1_248 2.118e-16
LSG_249 SG_249 SG_250 1.1624e-11
CCG_249 A1_249 B1_249 2.118e-16
LSG_250 SG_250 SG_251 1.1624e-11
CCG_250 A1_250 B1_250 2.118e-16
LSG_251 SG_251 SG_252 1.162e-11
CCG_251 A1_251 B1_251 2.117e-16
LSG_252 SG_252 SG_253 1.1584e-11
CCG_252 A1_252 B1_252 2.11e-16
LSG_253 SG_253 SG_254 1.1513e-11
CCG_253 A1_253 B1_253 2.097e-16
LSG_254 SG_254 SG_255 1.1406e-11
CCG_254 A1_254 B1_254 2.078e-16
LSG_255 SG_255 SG_256 1.1265e-11
CCG_255 A1_255 B1_255 2.052e-16
LSG_256 SG_256 SG_257 1.109e-11
CCG_256 A1_256 B1_256 2.021e-16
LSG_257 SG_257 SG_258 1.0883e-11
CCG_257 A1_257 B1_257 1.983e-16
LSG_258 SG_258 SG_259 1.0645e-11
CCG_258 A1_258 B1_258 1.939e-16
LSG_259 SG_259 SG_260 1.0377e-11
CCG_259 A1_259 B1_259 1.89e-16
LSG_260 SG_260 SG_261 1.008e-11
CCG_260 A1_260 B1_260 1.836e-16
LSG_261 SG_261 SG_262 9.7575e-12
CCG_261 A1_261 B1_261 1.778e-16
LSG_262 SG_262 SG_263 9.4104e-12
CCG_262 A1_262 B1_262 1.714e-16
LSG_263 SG_263 SG_264 9.0412e-12
CCG_263 A1_263 B1_263 1.647e-16
LSG_264 SG_264 SG_265 8.6521e-12
CCG_264 A1_264 B1_264 1.576e-16
LSG_265 SG_265 SG_266 8.2455e-12
CCG_265 A1_265 B1_265 1.502e-16
LSG_266 SG_266 SG_267 7.8239e-12
CCG_266 A1_266 B1_266 1.425e-16
LSG_267 SG_267 SG_268 7.3898e-12
CCG_267 A1_267 B1_267 1.346e-16
LSG_268 SG_268 SG_269 6.9461e-12
CCG_268 A1_268 B1_268 1.265e-16
LSG_269 SG_269 SG_270 6.4953e-12
CCG_269 A1_269 B1_269 1.183e-16
LSG_270 SG_270 SG_271 6.0404e-12
CCG_270 A1_270 B1_270 1.1e-16
LSG_271 SG_271 SG_272 5.584e-12
CCG_271 A1_271 B1_271 1.017e-16
LSG_272 SG_272 SG_273 5.129e-12
CCG_272 A1_272 B1_272 9.344e-17
LSG_273 SG_273 SG_274 4.6783e-12
CCG_273 A1_273 B1_273 8.523e-17
LSG_274 SG_274 SG_275 4.2345e-12
CCG_274 A1_274 B1_274 7.715e-17
LSG_275 SG_275 SG_276 3.8005e-12
CCG_275 A1_275 B1_275 6.924e-17
LSG_276 SG_276 SG_277 3.3788e-12
CCG_276 A1_276 B1_276 6.156e-17
LSG_277 SG_277 SG_278 2.9722e-12
CCG_277 A1_277 B1_277 5.415e-17
LSG_278 SG_278 SG_279 2.5831e-12
CCG_278 A1_278 B1_278 4.706e-17
LSG_279 SG_279 SG_280 2.2139e-12
CCG_279 A1_279 B1_279 4.033e-17
LSG_280 SG_280 SG_281 1.8669e-12
CCG_280 A1_280 B1_280 3.401e-17
LSG_281 SG_281 SG_282 1.5442e-12
CCG_281 A1_281 B1_281 2.813e-17
LSG_282 SG_282 SG_283 1.2478e-12
CCG_282 A1_282 B1_282 2.273e-17
LSG_283 SG_283 SG_284 9.7953e-13
CCG_283 A1_283 B1_283 1.785e-17
LSG_284 SG_284 SG_285 7.4107e-13
CCG_284 A1_284 B1_284 1.35e-17
LSG_285 SG_285 SG_286 5.3389e-13
CCG_285 A1_285 B1_285 9.727e-18
LSG_286 SG_286 SG_287 3.5924e-13
CCG_286 A1_286 B1_286 6.545e-18
LSG_287 SG_287 SG_288 2.1822e-13
CCG_287 A1_287 B1_287 3.976e-18
LSG_288 SG_288 SG_289 1.1168e-13
CCG_288 A1_288 B1_288 2.035e-18
LSG_289 SG_289 SG_290 4.0287e-14
CCG_289 A1_289 B1_289 7.34e-19
LSG_290 SG_290 0 4.481e-15
CCG_290 A1_290 B1_290 8.164e-20
LSG_entry SG_111 0 1p
LSDB_111 SDB_111 SDB_112 4.481e-15
CCDB_111 B0_111 D_B_111 8.164e-20
LSDB_112 SDB_112 SDB_113 4.0287e-14
CCDB_112 B0_112 D_B_112 7.34e-19
LSDB_113 SDB_113 SDB_114 1.1168e-13
CCDB_113 B0_113 D_B_113 2.035e-18
LSDB_114 SDB_114 SDB_115 2.1822e-13
CCDB_114 B0_114 D_B_114 3.976e-18
LSDB_115 SDB_115 SDB_116 3.5924e-13
CCDB_115 B0_115 D_B_115 6.545e-18
LSDB_116 SDB_116 SDB_117 5.3389e-13
CCDB_116 B0_116 D_B_116 9.727e-18
LSDB_117 SDB_117 SDB_118 7.4107e-13
CCDB_117 B0_117 D_B_117 1.35e-17
LSDB_118 SDB_118 SDB_119 9.7953e-13
CCDB_118 B0_118 D_B_118 1.785e-17
LSDB_119 SDB_119 SDB_120 1.2478e-12
CCDB_119 B0_119 D_B_119 2.273e-17
LSDB_120 SDB_120 SDB_121 1.5442e-12
CCDB_120 B0_120 D_B_120 2.813e-17
LSDB_121 SDB_121 SDB_122 1.8669e-12
CCDB_121 B0_121 D_B_121 3.401e-17
LSDB_122 SDB_122 SDB_123 2.2139e-12
CCDB_122 B0_122 D_B_122 4.033e-17
LSDB_123 SDB_123 SDB_124 2.5831e-12
CCDB_123 B0_123 D_B_123 4.706e-17
LSDB_124 SDB_124 SDB_125 2.9722e-12
CCDB_124 B0_124 D_B_124 5.415e-17
LSDB_125 SDB_125 SDB_126 3.3788e-12
CCDB_125 B0_125 D_B_125 6.156e-17
LSDB_126 SDB_126 SDB_127 3.8005e-12
CCDB_126 B0_126 D_B_126 6.924e-17
LSDB_127 SDB_127 SDB_128 4.2345e-12
CCDB_127 B0_127 D_B_127 7.715e-17
LSDB_128 SDB_128 SDB_129 4.6783e-12
CCDB_128 B0_128 D_B_128 8.523e-17
LSDB_129 SDB_129 SDB_130 5.129e-12
CCDB_129 B0_129 D_B_129 9.344e-17
LSDB_130 SDB_130 SDB_131 5.584e-12
CCDB_130 B0_130 D_B_130 1.017e-16
LSDB_131 SDB_131 SDB_132 6.0404e-12
CCDB_131 B0_131 D_B_131 1.1e-16
LSDB_132 SDB_132 SDB_133 6.4953e-12
CCDB_132 B0_132 D_B_132 1.183e-16
LSDB_133 SDB_133 SDB_134 6.9461e-12
CCDB_133 B0_133 D_B_133 1.265e-16
LSDB_134 SDB_134 SDB_135 7.3898e-12
CCDB_134 B0_134 D_B_134 1.346e-16
LSDB_135 SDB_135 SDB_136 7.8239e-12
CCDB_135 B0_135 D_B_135 1.425e-16
LSDB_136 SDB_136 SDB_137 8.2455e-12
CCDB_136 B0_136 D_B_136 1.502e-16
LSDB_137 SDB_137 SDB_138 8.6521e-12
CCDB_137 B0_137 D_B_137 1.576e-16
LSDB_138 SDB_138 SDB_139 9.0412e-12
CCDB_138 B0_138 D_B_138 1.647e-16
LSDB_139 SDB_139 SDB_140 9.4104e-12
CCDB_139 B0_139 D_B_139 1.714e-16
LSDB_140 SDB_140 SDB_141 9.7575e-12
CCDB_140 B0_140 D_B_140 1.778e-16
LSDB_141 SDB_141 SDB_142 1.008e-11
CCDB_141 B0_141 D_B_141 1.836e-16
LSDB_142 SDB_142 SDB_143 1.0377e-11
CCDB_142 B0_142 D_B_142 1.89e-16
LSDB_143 SDB_143 SDB_144 1.0645e-11
CCDB_143 B0_143 D_B_143 1.939e-16
LSDB_144 SDB_144 SDB_145 1.0883e-11
CCDB_144 B0_144 D_B_144 1.983e-16
LSDB_145 SDB_145 SDB_146 1.109e-11
CCDB_145 B0_145 D_B_145 2.021e-16
LSDB_146 SDB_146 SDB_147 1.1265e-11
CCDB_146 B0_146 D_B_146 2.052e-16
LSDB_147 SDB_147 SDB_148 1.1406e-11
CCDB_147 B0_147 D_B_147 2.078e-16
LSDB_148 SDB_148 SDB_149 1.1513e-11
CCDB_148 B0_148 D_B_148 2.097e-16
LSDB_149 SDB_149 SDB_150 1.1584e-11
CCDB_149 B0_149 D_B_149 2.11e-16
LSDB_150 SDB_150 SDB_151 1.162e-11
CCDB_150 B0_150 D_B_150 2.117e-16
LSDB_151 SDB_151 SDB_152 1.1624e-11
CCDB_151 B0_151 D_B_151 2.118e-16
LSDB_152 SDB_152 SDB_153 1.1624e-11
CCDB_152 B0_152 D_B_152 2.118e-16
LSDB_153 SDB_153 SDB_154 1.1624e-11
CCDB_153 B0_153 D_B_153 2.118e-16
LSDB_154 SDB_154 SDB_155 1.1624e-11
CCDB_154 B0_154 D_B_154 2.118e-16
LSDB_155 SDB_155 SDB_156 1.1624e-11
CCDB_155 B0_155 D_B_155 2.118e-16
LSDB_156 SDB_156 SDB_157 1.1624e-11
CCDB_156 B0_156 D_B_156 2.118e-16
LSDB_157 SDB_157 SDB_158 1.1624e-11
CCDB_157 B0_157 D_B_157 2.118e-16
LSDB_158 SDB_158 SDB_159 1.1624e-11
CCDB_158 B0_158 D_B_158 2.118e-16
LSDB_159 SDB_159 SDB_160 1.1624e-11
CCDB_159 B0_159 D_B_159 2.118e-16
LSDB_160 SDB_160 SDB_161 1.1624e-11
CCDB_160 B0_160 D_B_160 2.118e-16
LSDB_161 SDB_161 SDB_162 1.1624e-11
CCDB_161 B0_161 D_B_161 2.118e-16
LSDB_162 SDB_162 SDB_163 1.1624e-11
CCDB_162 B0_162 D_B_162 2.118e-16
LSDB_163 SDB_163 SDB_164 1.1624e-11
CCDB_163 B0_163 D_B_163 2.118e-16
LSDB_164 SDB_164 SDB_165 1.1624e-11
CCDB_164 B0_164 D_B_164 2.118e-16
LSDB_165 SDB_165 SDB_166 1.1624e-11
CCDB_165 B0_165 D_B_165 2.118e-16
LSDB_166 SDB_166 SDB_167 1.1624e-11
CCDB_166 B0_166 D_B_166 2.118e-16
LSDB_167 SDB_167 SDB_168 1.1624e-11
CCDB_167 B0_167 D_B_167 2.118e-16
LSDB_168 SDB_168 SDB_169 1.1624e-11
CCDB_168 B0_168 D_B_168 2.118e-16
LSDB_169 SDB_169 SDB_170 1.1624e-11
CCDB_169 B0_169 D_B_169 2.118e-16
LSDB_170 SDB_170 SDB_171 1.1624e-11
CCDB_170 B0_170 D_B_170 2.118e-16
LSDB_171 SDB_171 SDB_172 1.1624e-11
CCDB_171 B0_171 D_B_171 2.118e-16
LSDB_172 SDB_172 SDB_173 1.1624e-11
CCDB_172 B0_172 D_B_172 2.118e-16
LSDB_173 SDB_173 SDB_174 1.1624e-11
CCDB_173 B0_173 D_B_173 2.118e-16
LSDB_174 SDB_174 SDB_175 1.1624e-11
CCDB_174 B0_174 D_B_174 2.118e-16
LSDB_175 SDB_175 SDB_176 1.1624e-11
CCDB_175 B0_175 D_B_175 2.118e-16
LSDB_176 SDB_176 SDB_177 1.1624e-11
CCDB_176 B0_176 D_B_176 2.118e-16
LSDB_177 SDB_177 SDB_178 1.1624e-11
CCDB_177 B0_177 D_B_177 2.118e-16
LSDB_178 SDB_178 SDB_179 1.1624e-11
CCDB_178 B0_178 D_B_178 2.118e-16
LSDB_179 SDB_179 SDB_180 1.1624e-11
CCDB_179 B0_179 D_B_179 2.118e-16
LSDB_180 SDB_180 SDB_181 1.1624e-11
CCDB_180 B0_180 D_B_180 2.118e-16
LSDB_181 SDB_181 SDB_182 1.1624e-11
CCDB_181 B0_181 D_B_181 2.118e-16
LSDB_182 SDB_182 SDB_183 1.1624e-11
CCDB_182 B0_182 D_B_182 2.118e-16
LSDB_183 SDB_183 SDB_184 1.1624e-11
CCDB_183 B0_183 D_B_183 2.118e-16
LSDB_184 SDB_184 SDB_185 1.1624e-11
CCDB_184 B0_184 D_B_184 2.118e-16
LSDB_185 SDB_185 SDB_186 1.1624e-11
CCDB_185 B0_185 D_B_185 2.118e-16
LSDB_186 SDB_186 SDB_187 1.1624e-11
CCDB_186 B0_186 D_B_186 2.118e-16
LSDB_187 SDB_187 SDB_188 1.1624e-11
CCDB_187 B0_187 D_B_187 2.118e-16
LSDB_188 SDB_188 SDB_189 1.1624e-11
CCDB_188 B0_188 D_B_188 2.118e-16
LSDB_189 SDB_189 SDB_190 1.1624e-11
CCDB_189 B0_189 D_B_189 2.118e-16
LSDB_190 SDB_190 SDB_191 1.1624e-11
CCDB_190 B0_190 D_B_190 2.118e-16
LSDB_191 SDB_191 SDB_192 1.1624e-11
CCDB_191 B0_191 D_B_191 2.118e-16
LSDB_192 SDB_192 SDB_193 1.1624e-11
CCDB_192 B0_192 D_B_192 2.118e-16
LSDB_193 SDB_193 SDB_194 1.1624e-11
CCDB_193 B0_193 D_B_193 2.118e-16
LSDB_194 SDB_194 SDB_195 1.1624e-11
CCDB_194 B0_194 D_B_194 2.118e-16
LSDB_195 SDB_195 SDB_196 1.1624e-11
CCDB_195 B0_195 D_B_195 2.118e-16
LSDB_196 SDB_196 SDB_197 1.1624e-11
CCDB_196 B0_196 D_B_196 2.118e-16
LSDB_197 SDB_197 SDB_198 1.1624e-11
CCDB_197 B0_197 D_B_197 2.118e-16
LSDB_198 SDB_198 SDB_199 1.1624e-11
CCDB_198 B0_198 D_B_198 2.118e-16
LSDB_199 SDB_199 SDB_200 1.1624e-11
CCDB_199 B0_199 D_B_199 2.118e-16
LSDB_200 SDB_200 SDB_201 1.1624e-11
CCDB_200 B0_200 D_B_200 2.118e-16
LSDB_201 SDB_201 SDB_202 1.1624e-11
CCDB_201 B0_201 D_B_201 2.118e-16
LSDB_202 SDB_202 SDB_203 1.1624e-11
CCDB_202 B0_202 D_B_202 2.118e-16
LSDB_203 SDB_203 SDB_204 1.1624e-11
CCDB_203 B0_203 D_B_203 2.118e-16
LSDB_204 SDB_204 SDB_205 1.1624e-11
CCDB_204 B0_204 D_B_204 2.118e-16
LSDB_205 SDB_205 SDB_206 1.1624e-11
CCDB_205 B0_205 D_B_205 2.118e-16
LSDB_206 SDB_206 SDB_207 1.1624e-11
CCDB_206 B0_206 D_B_206 2.118e-16
LSDB_207 SDB_207 SDB_208 1.1624e-11
CCDB_207 B0_207 D_B_207 2.118e-16
LSDB_208 SDB_208 SDB_209 1.1624e-11
CCDB_208 B0_208 D_B_208 2.118e-16
LSDB_209 SDB_209 SDB_210 1.1624e-11
CCDB_209 B0_209 D_B_209 2.118e-16
LSDB_210 SDB_210 SDB_211 1.1624e-11
CCDB_210 B0_210 D_B_210 2.118e-16
LSDB_211 SDB_211 SDB_212 1.1624e-11
CCDB_211 B0_211 D_B_211 2.118e-16
LSDB_212 SDB_212 SDB_213 1.1624e-11
CCDB_212 B0_212 D_B_212 2.118e-16
LSDB_213 SDB_213 SDB_214 1.1624e-11
CCDB_213 B0_213 D_B_213 2.118e-16
LSDB_214 SDB_214 SDB_215 1.1624e-11
CCDB_214 B0_214 D_B_214 2.118e-16
LSDB_215 SDB_215 SDB_216 1.1624e-11
CCDB_215 B0_215 D_B_215 2.118e-16
LSDB_216 SDB_216 SDB_217 1.1624e-11
CCDB_216 B0_216 D_B_216 2.118e-16
LSDB_217 SDB_217 SDB_218 1.1624e-11
CCDB_217 B0_217 D_B_217 2.118e-16
LSDB_218 SDB_218 SDB_219 1.1624e-11
CCDB_218 B0_218 D_B_218 2.118e-16
LSDB_219 SDB_219 SDB_220 1.1624e-11
CCDB_219 B0_219 D_B_219 2.118e-16
LSDB_220 SDB_220 SDB_221 1.1624e-11
CCDB_220 B0_220 D_B_220 2.118e-16
LSDB_221 SDB_221 SDB_222 1.1624e-11
CCDB_221 B0_221 D_B_221 2.118e-16
LSDB_222 SDB_222 SDB_223 1.1624e-11
CCDB_222 B0_222 D_B_222 2.118e-16
LSDB_223 SDB_223 SDB_224 1.1624e-11
CCDB_223 B0_223 D_B_223 2.118e-16
LSDB_224 SDB_224 SDB_225 1.1624e-11
CCDB_224 B0_224 D_B_224 2.118e-16
LSDB_225 SDB_225 SDB_226 1.1624e-11
CCDB_225 B0_225 D_B_225 2.118e-16
LSDB_226 SDB_226 SDB_227 1.1624e-11
CCDB_226 B0_226 D_B_226 2.118e-16
LSDB_227 SDB_227 SDB_228 1.1624e-11
CCDB_227 B0_227 D_B_227 2.118e-16
LSDB_228 SDB_228 SDB_229 1.1624e-11
CCDB_228 B0_228 D_B_228 2.118e-16
LSDB_229 SDB_229 SDB_230 1.1624e-11
CCDB_229 B0_229 D_B_229 2.118e-16
LSDB_230 SDB_230 SDB_231 1.1624e-11
CCDB_230 B0_230 D_B_230 2.118e-16
LSDB_231 SDB_231 SDB_232 1.1624e-11
CCDB_231 B0_231 D_B_231 2.118e-16
LSDB_232 SDB_232 SDB_233 1.1624e-11
CCDB_232 B0_232 D_B_232 2.118e-16
LSDB_233 SDB_233 SDB_234 1.1624e-11
CCDB_233 B0_233 D_B_233 2.118e-16
LSDB_234 SDB_234 SDB_235 1.1624e-11
CCDB_234 B0_234 D_B_234 2.118e-16
LSDB_235 SDB_235 SDB_236 1.1624e-11
CCDB_235 B0_235 D_B_235 2.118e-16
LSDB_236 SDB_236 SDB_237 1.1624e-11
CCDB_236 B0_236 D_B_236 2.118e-16
LSDB_237 SDB_237 SDB_238 1.1624e-11
CCDB_237 B0_237 D_B_237 2.118e-16
LSDB_238 SDB_238 SDB_239 1.1624e-11
CCDB_238 B0_238 D_B_238 2.118e-16
LSDB_239 SDB_239 SDB_240 1.1624e-11
CCDB_239 B0_239 D_B_239 2.118e-16
LSDB_240 SDB_240 SDB_241 1.1624e-11
CCDB_240 B0_240 D_B_240 2.118e-16
LSDB_241 SDB_241 SDB_242 1.1624e-11
CCDB_241 B0_241 D_B_241 2.118e-16
LSDB_242 SDB_242 SDB_243 1.1624e-11
CCDB_242 B0_242 D_B_242 2.118e-16
LSDB_243 SDB_243 SDB_244 1.1624e-11
CCDB_243 B0_243 D_B_243 2.118e-16
LSDB_244 SDB_244 SDB_245 1.1624e-11
CCDB_244 B0_244 D_B_244 2.118e-16
LSDB_245 SDB_245 SDB_246 1.1624e-11
CCDB_245 B0_245 D_B_245 2.118e-16
LSDB_246 SDB_246 SDB_247 1.1624e-11
CCDB_246 B0_246 D_B_246 2.118e-16
LSDB_247 SDB_247 SDB_248 1.1624e-11
CCDB_247 B0_247 D_B_247 2.118e-16
LSDB_248 SDB_248 SDB_249 1.1624e-11
CCDB_248 B0_248 D_B_248 2.118e-16
LSDB_249 SDB_249 SDB_250 1.1624e-11
CCDB_249 B0_249 D_B_249 2.118e-16
LSDB_250 SDB_250 SDB_251 1.1624e-11
CCDB_250 B0_250 D_B_250 2.118e-16
LSDB_251 SDB_251 SDB_252 1.162e-11
CCDB_251 B0_251 D_B_251 2.117e-16
LSDB_252 SDB_252 SDB_253 1.1584e-11
CCDB_252 B0_252 D_B_252 2.11e-16
LSDB_253 SDB_253 SDB_254 1.1513e-11
CCDB_253 B0_253 D_B_253 2.097e-16
LSDB_254 SDB_254 SDB_255 1.1406e-11
CCDB_254 B0_254 D_B_254 2.078e-16
LSDB_255 SDB_255 SDB_256 1.1265e-11
CCDB_255 B0_255 D_B_255 2.052e-16
LSDB_256 SDB_256 SDB_257 1.109e-11
CCDB_256 B0_256 D_B_256 2.021e-16
LSDB_257 SDB_257 SDB_258 1.0883e-11
CCDB_257 B0_257 D_B_257 1.983e-16
LSDB_258 SDB_258 SDB_259 1.0645e-11
CCDB_258 B0_258 D_B_258 1.939e-16
LSDB_259 SDB_259 SDB_260 1.0377e-11
CCDB_259 B0_259 D_B_259 1.89e-16
LSDB_260 SDB_260 SDB_261 1.008e-11
CCDB_260 B0_260 D_B_260 1.836e-16
LSDB_261 SDB_261 SDB_262 9.7575e-12
CCDB_261 B0_261 D_B_261 1.778e-16
LSDB_262 SDB_262 SDB_263 9.4104e-12
CCDB_262 B0_262 D_B_262 1.714e-16
LSDB_263 SDB_263 SDB_264 9.0412e-12
CCDB_263 B0_263 D_B_263 1.647e-16
LSDB_264 SDB_264 SDB_265 8.6521e-12
CCDB_264 B0_264 D_B_264 1.576e-16
LSDB_265 SDB_265 SDB_266 8.2455e-12
CCDB_265 B0_265 D_B_265 1.502e-16
LSDB_266 SDB_266 SDB_267 7.8239e-12
CCDB_266 B0_266 D_B_266 1.425e-16
LSDB_267 SDB_267 SDB_268 7.3898e-12
CCDB_267 B0_267 D_B_267 1.346e-16
LSDB_268 SDB_268 SDB_269 6.9461e-12
CCDB_268 B0_268 D_B_268 1.265e-16
LSDB_269 SDB_269 SDB_270 6.4953e-12
CCDB_269 B0_269 D_B_269 1.183e-16
LSDB_270 SDB_270 SDB_271 6.0404e-12
CCDB_270 B0_270 D_B_270 1.1e-16
LSDB_271 SDB_271 SDB_272 5.584e-12
CCDB_271 B0_271 D_B_271 1.017e-16
LSDB_272 SDB_272 SDB_273 5.129e-12
CCDB_272 B0_272 D_B_272 9.344e-17
LSDB_273 SDB_273 SDB_274 4.6783e-12
CCDB_273 B0_273 D_B_273 8.523e-17
LSDB_274 SDB_274 SDB_275 4.2345e-12
CCDB_274 B0_274 D_B_274 7.715e-17
LSDB_275 SDB_275 SDB_276 3.8005e-12
CCDB_275 B0_275 D_B_275 6.924e-17
LSDB_276 SDB_276 SDB_277 3.3788e-12
CCDB_276 B0_276 D_B_276 6.156e-17
LSDB_277 SDB_277 SDB_278 2.9722e-12
CCDB_277 B0_277 D_B_277 5.415e-17
LSDB_278 SDB_278 SDB_279 2.5831e-12
CCDB_278 B0_278 D_B_278 4.706e-17
LSDB_279 SDB_279 SDB_280 2.2139e-12
CCDB_279 B0_279 D_B_279 4.033e-17
LSDB_280 SDB_280 SDB_281 1.8669e-12
CCDB_280 B0_280 D_B_280 3.401e-17
LSDB_281 SDB_281 SDB_282 1.5442e-12
CCDB_281 B0_281 D_B_281 2.813e-17
LSDB_282 SDB_282 SDB_283 1.2478e-12
CCDB_282 B0_282 D_B_282 2.273e-17
LSDB_283 SDB_283 SDB_284 9.7953e-13
CCDB_283 B0_283 D_B_283 1.785e-17
LSDB_284 SDB_284 SDB_285 7.4107e-13
CCDB_284 B0_284 D_B_284 1.35e-17
LSDB_285 SDB_285 SDB_286 5.3389e-13
CCDB_285 B0_285 D_B_285 9.727e-18
LSDB_286 SDB_286 SDB_287 3.5924e-13
CCDB_286 B0_286 D_B_286 6.545e-18
LSDB_287 SDB_287 SDB_288 2.1822e-13
CCDB_287 B0_287 D_B_287 3.976e-18
LSDB_288 SDB_288 SDB_289 1.1168e-13
CCDB_288 B0_288 D_B_288 2.035e-18
LSDB_289 SDB_289 SDB_290 4.0287e-14
CCDB_289 B0_289 D_B_289 7.34e-19
LSDB_290 SDB_290 0 4.481e-15
CCDB_290 B0_290 D_B_290 8.164e-20
LSDB_entry SDB_111 0 1p
BMA_50 MA_50 MA_51 JJM area=1
CMA_50 MA_50 MA_51 3.124e-16
BMA_51 MA_51 MA_52 JJM area=1
CMA_51 MA_51 MA_52 3.124e-16
BMA_52 MA_52 MA_53 JJM area=1
CMA_52 MA_52 MA_53 3.124e-16
BMA_53 MA_53 MA_54 JJM area=1
CMA_53 MA_53 MA_54 3.124e-16
BMA_54 MA_54 MA_55 JJM area=1
CMA_54 MA_54 MA_55 3.124e-16
BMA_55 MA_55 MA_56 JJM area=1
CMA_55 MA_55 MA_56 3.124e-16
BMA_56 MA_56 MA_57 JJM area=1
CMA_56 MA_56 MA_57 3.124e-16
BMA_57 MA_57 MA_58 JJM area=1
CMA_57 MA_57 MA_58 3.124e-16
BMA_58 MA_58 MA_59 JJM area=1
CMA_58 MA_58 MA_59 3.124e-16
BMA_59 MA_59 MA_60 JJM area=1
CMA_59 MA_59 MA_60 3.124e-16
BMA_60 MA_60 MA_61 JJM area=1
CMA_60 MA_60 MA_61 3.124e-16
BMA_61 MA_61 MA_62 JJM area=1
CMA_61 MA_61 MA_62 3.124e-16
BMA_62 MA_62 MA_63 JJM area=1
CMA_62 MA_62 MA_63 3.124e-16
BMA_63 MA_63 MA_64 JJM area=1
CMA_63 MA_63 MA_64 3.124e-16
BMA_64 MA_64 MA_65 JJM area=1
CMA_64 MA_64 MA_65 3.124e-16
BMA_65 MA_65 MA_66 JJM area=1
CMA_65 MA_65 MA_66 3.124e-16
BMA_66 MA_66 MA_67 JJM area=1
CMA_66 MA_66 MA_67 3.124e-16
BMA_67 MA_67 MA_68 JJM area=1
CMA_67 MA_67 MA_68 3.124e-16
BMA_68 MA_68 MA_69 JJM area=1
CMA_68 MA_68 MA_69 3.124e-16
BMA_69 MA_69 MA_70 JJM area=1
CMA_69 MA_69 MA_70 3.124e-16
BMA_70 MA_70 MA_71 JJM area=1
CMA_70 MA_70 MA_71 3.124e-16
BMA_71 MA_71 MA_72 JJM area=1
CMA_71 MA_71 MA_72 3.124e-16
BMA_72 MA_72 MA_73 JJM area=1
CMA_72 MA_72 MA_73 3.124e-16
BMA_73 MA_73 MA_74 JJM area=1
CMA_73 MA_73 MA_74 3.124e-16
BMA_74 MA_74 MA_75 JJM area=1
CMA_74 MA_74 MA_75 3.124e-16
BMA_75 MA_75 MA_76 JJM area=1
CMA_75 MA_75 MA_76 3.124e-16
BMA_76 MA_76 MA_77 JJM area=1
CMA_76 MA_76 MA_77 3.124e-16
BMA_77 MA_77 MA_78 JJM area=1
CMA_77 MA_77 MA_78 3.124e-16
BMA_78 MA_78 MA_79 JJM area=1
CMA_78 MA_78 MA_79 3.124e-16
BMA_79 MA_79 MA_80 JJM area=1
CMA_79 MA_79 MA_80 3.124e-16
BMA_80 MA_80 MA_81 JJM area=1
CMA_80 MA_80 MA_81 3.124e-16
BMA_81 MA_81 MA_82 JJM area=1
CMA_81 MA_81 MA_82 3.124e-16
BMA_82 MA_82 MA_83 JJM area=1
CMA_82 MA_82 MA_83 3.124e-16
BMA_83 MA_83 MA_84 JJM area=1
CMA_83 MA_83 MA_84 3.124e-16
BMA_84 MA_84 MA_85 JJM area=1
CMA_84 MA_84 MA_85 3.124e-16
BMA_85 MA_85 MA_86 JJM area=1
CMA_85 MA_85 MA_86 3.124e-16
BMA_86 MA_86 MA_87 JJM area=1
CMA_86 MA_86 MA_87 3.124e-16
BMA_87 MA_87 MA_88 JJM area=1
CMA_87 MA_87 MA_88 3.124e-16
BMA_88 MA_88 MA_89 JJM area=1
CMA_88 MA_88 MA_89 3.124e-16
BMA_89 MA_89 MA_90 JJM area=1
CMA_89 MA_89 MA_90 3.124e-16
LMA_BS_prep_end MA_90 0 1p
LMA_BS_prep_start MA_50 0 1p
BMA_311 MA_311 MA_312 JJM area=1
CMA_311 MA_311 MA_312 3.124e-16
BMA_312 MA_312 MA_313 JJM area=1
CMA_312 MA_312 MA_313 3.124e-16
BMA_313 MA_313 MA_314 JJM area=1
CMA_313 MA_313 MA_314 3.124e-16
BMA_314 MA_314 MA_315 JJM area=1
CMA_314 MA_314 MA_315 3.124e-16
BMA_315 MA_315 MA_316 JJM area=1
CMA_315 MA_315 MA_316 3.124e-16
BMA_316 MA_316 MA_317 JJM area=1
CMA_316 MA_316 MA_317 3.124e-16
BMA_317 MA_317 MA_318 JJM area=1
CMA_317 MA_317 MA_318 3.124e-16
BMA_318 MA_318 MA_319 JJM area=1
CMA_318 MA_318 MA_319 3.124e-16
BMA_319 MA_319 MA_320 JJM area=1
CMA_319 MA_319 MA_320 3.124e-16
BMA_320 MA_320 MA_321 JJM area=1
CMA_320 MA_320 MA_321 3.124e-16
BMA_321 MA_321 MA_322 JJM area=1
CMA_321 MA_321 MA_322 3.124e-16
BMA_322 MA_322 MA_323 JJM area=1
CMA_322 MA_322 MA_323 3.124e-16
BMA_323 MA_323 MA_324 JJM area=1
CMA_323 MA_323 MA_324 3.124e-16
BMA_324 MA_324 MA_325 JJM area=1
CMA_324 MA_324 MA_325 3.124e-16
BMA_325 MA_325 MA_326 JJM area=1
CMA_325 MA_325 MA_326 3.124e-16
BMA_326 MA_326 MA_327 JJM area=1
CMA_326 MA_326 MA_327 3.124e-16
BMA_327 MA_327 MA_328 JJM area=1
CMA_327 MA_327 MA_328 3.124e-16
BMA_328 MA_328 MA_329 JJM area=1
CMA_328 MA_328 MA_329 3.124e-16
BMA_329 MA_329 MA_330 JJM area=1
CMA_329 MA_329 MA_330 3.124e-16
BMA_330 MA_330 MA_331 JJM area=1
CMA_330 MA_330 MA_331 3.124e-16
BMA_331 MA_331 MA_332 JJM area=1
CMA_331 MA_331 MA_332 3.124e-16
BMA_332 MA_332 MA_333 JJM area=1
CMA_332 MA_332 MA_333 3.124e-16
BMA_333 MA_333 MA_334 JJM area=1
CMA_333 MA_333 MA_334 3.124e-16
BMA_334 MA_334 MA_335 JJM area=1
CMA_334 MA_334 MA_335 3.124e-16
BMA_335 MA_335 MA_336 JJM area=1
CMA_335 MA_335 MA_336 3.124e-16
BMA_336 MA_336 MA_337 JJM area=1
CMA_336 MA_336 MA_337 3.124e-16
BMA_337 MA_337 MA_338 JJM area=1
CMA_337 MA_337 MA_338 3.124e-16
BMA_338 MA_338 MA_339 JJM area=1
CMA_338 MA_338 MA_339 3.124e-16
BMA_339 MA_339 MA_340 JJM area=1
CMA_339 MA_339 MA_340 3.124e-16
BMA_340 MA_340 MA_341 JJM area=1
CMA_340 MA_340 MA_341 3.124e-16
BMA_341 MA_341 MA_342 JJM area=1
CMA_341 MA_341 MA_342 3.124e-16
BMA_342 MA_342 MA_343 JJM area=1
CMA_342 MA_342 MA_343 3.124e-16
BMA_343 MA_343 MA_344 JJM area=1
CMA_343 MA_343 MA_344 3.124e-16
BMA_344 MA_344 MA_345 JJM area=1
CMA_344 MA_344 MA_345 3.124e-16
BMA_345 MA_345 MA_346 JJM area=1
CMA_345 MA_345 MA_346 3.124e-16
BMA_346 MA_346 MA_347 JJM area=1
CMA_346 MA_346 MA_347 3.124e-16
BMA_347 MA_347 MA_348 JJM area=1
CMA_347 MA_347 MA_348 3.124e-16
BMA_348 MA_348 MA_349 JJM area=1
CMA_348 MA_348 MA_349 3.124e-16
BMA_349 MA_349 MA_350 JJM area=1
CMA_349 MA_349 MA_350 3.124e-16
BMA_350 MA_350 MA_351 JJM area=1
CMA_350 MA_350 MA_351 3.124e-16
LMA_BS_analysis_end MA_351 0 1p
LMA_BS_analysis_start MA_311 0 1p
BMB_271 MB_271 MB_272 JJM area=1
CMB_271 MB_271 MB_272 3.124e-16
BMB_272 MB_272 MB_273 JJM area=1
CMB_272 MB_272 MB_273 3.124e-16
BMB_273 MB_273 MB_274 JJM area=1
CMB_273 MB_273 MB_274 3.124e-16
BMB_274 MB_274 MB_275 JJM area=1
CMB_274 MB_274 MB_275 3.124e-16
BMB_275 MB_275 MB_276 JJM area=1
CMB_275 MB_275 MB_276 3.124e-16
BMB_276 MB_276 MB_277 JJM area=1
CMB_276 MB_276 MB_277 3.124e-16
BMB_277 MB_277 MB_278 JJM area=1
CMB_277 MB_277 MB_278 3.124e-16
BMB_278 MB_278 MB_279 JJM area=1
CMB_278 MB_278 MB_279 3.124e-16
BMB_279 MB_279 MB_280 JJM area=1
CMB_279 MB_279 MB_280 3.124e-16
BMB_280 MB_280 MB_281 JJM area=1
CMB_280 MB_280 MB_281 3.124e-16
BMB_281 MB_281 MB_282 JJM area=1
CMB_281 MB_281 MB_282 3.124e-16
BMB_282 MB_282 MB_283 JJM area=1
CMB_282 MB_282 MB_283 3.124e-16
BMB_283 MB_283 MB_284 JJM area=1
CMB_283 MB_283 MB_284 3.124e-16
BMB_284 MB_284 MB_285 JJM area=1
CMB_284 MB_284 MB_285 3.124e-16
BMB_285 MB_285 MB_286 JJM area=1
CMB_285 MB_285 MB_286 3.124e-16
BMB_286 MB_286 MB_287 JJM area=1
CMB_286 MB_286 MB_287 3.124e-16
BMB_287 MB_287 MB_288 JJM area=1
CMB_287 MB_287 MB_288 3.124e-16
BMB_288 MB_288 MB_289 JJM area=1
CMB_288 MB_288 MB_289 3.124e-16
BMB_289 MB_289 MB_290 JJM area=1
CMB_289 MB_289 MB_290 3.124e-16
BMB_290 MB_290 MB_291 JJM area=1
CMB_290 MB_290 MB_291 3.124e-16
BMB_291 MB_291 MB_292 JJM area=1
CMB_291 MB_291 MB_292 3.124e-16
BMB_292 MB_292 MB_293 JJM area=1
CMB_292 MB_292 MB_293 3.124e-16
BMB_293 MB_293 MB_294 JJM area=1
CMB_293 MB_293 MB_294 3.124e-16
BMB_294 MB_294 MB_295 JJM area=1
CMB_294 MB_294 MB_295 3.124e-16
BMB_295 MB_295 MB_296 JJM area=1
CMB_295 MB_295 MB_296 3.124e-16
BMB_296 MB_296 MB_297 JJM area=1
CMB_296 MB_296 MB_297 3.124e-16
BMB_297 MB_297 MB_298 JJM area=1
CMB_297 MB_297 MB_298 3.124e-16
BMB_298 MB_298 MB_299 JJM area=1
CMB_298 MB_298 MB_299 3.124e-16
BMB_299 MB_299 MB_300 JJM area=1
CMB_299 MB_299 MB_300 3.124e-16
BMB_300 MB_300 MB_301 JJM area=1
CMB_300 MB_300 MB_301 3.124e-16
BMB_301 MB_301 MB_302 JJM area=1
CMB_301 MB_301 MB_302 3.124e-16
BMB_302 MB_302 MB_303 JJM area=1
CMB_302 MB_302 MB_303 3.124e-16
BMB_303 MB_303 MB_304 JJM area=1
CMB_303 MB_303 MB_304 3.124e-16
BMB_304 MB_304 MB_305 JJM area=1
CMB_304 MB_304 MB_305 3.124e-16
BMB_305 MB_305 MB_306 JJM area=1
CMB_305 MB_305 MB_306 3.124e-16
BMB_306 MB_306 MB_307 JJM area=1
CMB_306 MB_306 MB_307 3.124e-16
BMB_307 MB_307 MB_308 JJM area=1
CMB_307 MB_307 MB_308 3.124e-16
BMB_308 MB_308 MB_309 JJM area=1
CMB_308 MB_308 MB_309 3.124e-16
BMB_309 MB_309 MB_310 JJM area=1
CMB_309 MB_309 MB_310 3.124e-16
BMB_310 MB_310 MB_311 JJM area=1
CMB_310 MB_310 MB_311 3.124e-16
LMB_BS_prep_end MB_311 0 1p
LMB_BS_prep_start MB_271 0 1p
BMB_10 MB_10 MB_11 JJM area=1
CMB_10 MB_10 MB_11 3.124e-16
BMB_11 MB_11 MB_12 JJM area=1
CMB_11 MB_11 MB_12 3.124e-16
BMB_12 MB_12 MB_13 JJM area=1
CMB_12 MB_12 MB_13 3.124e-16
BMB_13 MB_13 MB_14 JJM area=1
CMB_13 MB_13 MB_14 3.124e-16
BMB_14 MB_14 MB_15 JJM area=1
CMB_14 MB_14 MB_15 3.124e-16
BMB_15 MB_15 MB_16 JJM area=1
CMB_15 MB_15 MB_16 3.124e-16
BMB_16 MB_16 MB_17 JJM area=1
CMB_16 MB_16 MB_17 3.124e-16
BMB_17 MB_17 MB_18 JJM area=1
CMB_17 MB_17 MB_18 3.124e-16
BMB_18 MB_18 MB_19 JJM area=1
CMB_18 MB_18 MB_19 3.124e-16
BMB_19 MB_19 MB_20 JJM area=1
CMB_19 MB_19 MB_20 3.124e-16
BMB_20 MB_20 MB_21 JJM area=1
CMB_20 MB_20 MB_21 3.124e-16
BMB_21 MB_21 MB_22 JJM area=1
CMB_21 MB_21 MB_22 3.124e-16
BMB_22 MB_22 MB_23 JJM area=1
CMB_22 MB_22 MB_23 3.124e-16
BMB_23 MB_23 MB_24 JJM area=1
CMB_23 MB_23 MB_24 3.124e-16
BMB_24 MB_24 MB_25 JJM area=1
CMB_24 MB_24 MB_25 3.124e-16
BMB_25 MB_25 MB_26 JJM area=1
CMB_25 MB_25 MB_26 3.124e-16
BMB_26 MB_26 MB_27 JJM area=1
CMB_26 MB_26 MB_27 3.124e-16
BMB_27 MB_27 MB_28 JJM area=1
CMB_27 MB_27 MB_28 3.124e-16
BMB_28 MB_28 MB_29 JJM area=1
CMB_28 MB_28 MB_29 3.124e-16
BMB_29 MB_29 MB_30 JJM area=1
CMB_29 MB_29 MB_30 3.124e-16
BMB_30 MB_30 MB_31 JJM area=1
CMB_30 MB_30 MB_31 3.124e-16
BMB_31 MB_31 MB_32 JJM area=1
CMB_31 MB_31 MB_32 3.124e-16
BMB_32 MB_32 MB_33 JJM area=1
CMB_32 MB_32 MB_33 3.124e-16
BMB_33 MB_33 MB_34 JJM area=1
CMB_33 MB_33 MB_34 3.124e-16
BMB_34 MB_34 MB_35 JJM area=1
CMB_34 MB_34 MB_35 3.124e-16
BMB_35 MB_35 MB_36 JJM area=1
CMB_35 MB_35 MB_36 3.124e-16
BMB_36 MB_36 MB_37 JJM area=1
CMB_36 MB_36 MB_37 3.124e-16
BMB_37 MB_37 MB_38 JJM area=1
CMB_37 MB_37 MB_38 3.124e-16
BMB_38 MB_38 MB_39 JJM area=1
CMB_38 MB_38 MB_39 3.124e-16
BMB_39 MB_39 MB_40 JJM area=1
CMB_39 MB_39 MB_40 3.124e-16
BMB_40 MB_40 MB_41 JJM area=1
CMB_40 MB_40 MB_41 3.124e-16
BMB_41 MB_41 MB_42 JJM area=1
CMB_41 MB_41 MB_42 3.124e-16
BMB_42 MB_42 MB_43 JJM area=1
CMB_42 MB_42 MB_43 3.124e-16
BMB_43 MB_43 MB_44 JJM area=1
CMB_43 MB_43 MB_44 3.124e-16
BMB_44 MB_44 MB_45 JJM area=1
CMB_44 MB_44 MB_45 3.124e-16
BMB_45 MB_45 MB_46 JJM area=1
CMB_45 MB_45 MB_46 3.124e-16
BMB_46 MB_46 MB_47 JJM area=1
CMB_46 MB_46 MB_47 3.124e-16
BMB_47 MB_47 MB_48 JJM area=1
CMB_47 MB_47 MB_48 3.124e-16
BMB_48 MB_48 MB_49 JJM area=1
CMB_48 MB_48 MB_49 3.124e-16
BMB_49 MB_49 MB_50 JJM area=1
CMB_49 MB_49 MB_50 3.124e-16
LMB_BS_analysis_end MB_50 0 1p
LMB_BS_analysis_start MB_10 0 1p
.tran 0.1p 3000p 0 0.1p
.print phase BA1_181
.print phase BB1_181
.end
